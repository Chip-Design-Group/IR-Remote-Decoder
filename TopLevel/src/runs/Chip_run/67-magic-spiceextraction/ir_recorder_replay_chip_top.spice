* NGSPICE file created from ir_recorder_replay_chip_top.ext - technology: ihp-sg13g2

* Black-box entry subcircuit for sg13g2_decap_8 abstract view
.subckt sg13g2_decap_8 VDD VSS
.ends

* Black-box entry subcircuit for sg13g2_fill_2 abstract view
.subckt sg13g2_fill_2 VDD VSS
.ends

* Black-box entry subcircuit for sg13g2_decap_4 abstract view
.subckt sg13g2_decap_4 VDD VSS
.ends

* Black-box entry subcircuit for sg13g2_o21ai_1 abstract view
.subckt sg13g2_o21ai_1 B1 VDD Y VSS A1 A2
.ends

* Black-box entry subcircuit for sg13g2_mux2_1 abstract view
.subckt sg13g2_mux2_1 A0 A1 S X VDD VSS
.ends

* Black-box entry subcircuit for sg13g2_fill_1 abstract view
.subckt sg13g2_fill_1 VDD VSS
.ends

* Black-box entry subcircuit for sg13g2_tiehi abstract view
.subckt sg13g2_tiehi VDD VSS L_HI
.ends

* Black-box entry subcircuit for sg13g2_a21oi_1 abstract view
.subckt sg13g2_a21oi_1 VSS VDD A1 A2 Y B1
.ends

* Black-box entry subcircuit for sg13g2_dfrbpq_1 abstract view
.subckt sg13g2_dfrbpq_1 RESET_B VSS VDD D Q CLK
.ends

* Black-box entry subcircuit for sg13g2_dlygate4sd3_1 abstract view
.subckt sg13g2_dlygate4sd3_1 A VDD VSS X
.ends

* Black-box entry subcircuit for sg13g2_nand2b_1 abstract view
.subckt sg13g2_nand2b_1 Y B A_N VDD VSS
.ends

* Black-box entry subcircuit for sg13g2_nand2_1 abstract view
.subckt sg13g2_nand2_1 Y A B VDD VSS
.ends

* Black-box entry subcircuit for sg13g2_a21o_1 abstract view
.subckt sg13g2_a21o_1 A2 A1 B1 X VDD VSS
.ends

* Black-box entry subcircuit for sg13g2_and2_1 abstract view
.subckt sg13g2_and2_1 A B X VDD VSS
.ends

* Black-box entry subcircuit for sg13g2_or2_1 abstract view
.subckt sg13g2_or2_1 VSS VDD X B A
.ends

* Black-box entry subcircuit for sg13g2_inv_1 abstract view
.subckt sg13g2_inv_1 VDD Y A VSS
.ends

* Black-box entry subcircuit for sg13g2_buf_1 abstract view
.subckt sg13g2_buf_1 A X VDD VSS
.ends

* Black-box entry subcircuit for sg13g2_nor2_1 abstract view
.subckt sg13g2_nor2_1 A B Y VDD VSS
.ends

* Black-box entry subcircuit for sg13g2_nand3b_1 abstract view
.subckt sg13g2_nand3b_1 B C Y VDD VSS A_N
.ends

* Black-box entry subcircuit for sg13g2_a22oi_1 abstract view
.subckt sg13g2_a22oi_1 Y B1 B2 A2 A1 VDD VSS
.ends

* Black-box entry subcircuit for sg13g2_buf_8 abstract view
.subckt sg13g2_buf_8 A X VDD VSS
.ends

* Black-box entry subcircuit for sg13g2_xnor2_1 abstract view
.subckt sg13g2_xnor2_1 Y A B VDD VSS
.ends

* Black-box entry subcircuit for sg13g2_nand3_1 abstract view
.subckt sg13g2_nand3_1 B C A Y VDD VSS
.ends

* Black-box entry subcircuit for sg13g2_xor2_1 abstract view
.subckt sg13g2_xor2_1 B A X VDD VSS
.ends

* Black-box entry subcircuit for sg13g2_mux4_1 abstract view
.subckt sg13g2_mux4_1 S0 A0 A1 A2 A3 S1 X VDD VSS
.ends

* Black-box entry subcircuit for sg13g2_a221oi_1 abstract view
.subckt sg13g2_a221oi_1 VDD VSS B2 C1 B1 A1 Y A2
.ends

* Black-box entry subcircuit for sg13g2_nor3_1 abstract view
.subckt sg13g2_nor3_1 A B C Y VDD VSS
.ends

* Black-box entry subcircuit for sg13g2_or3_1 abstract view
.subckt sg13g2_or3_1 A B C X VDD VSS
.ends

* Black-box entry subcircuit for sg13g2_nor4_1 abstract view
.subckt sg13g2_nor4_1 A B C D Y VDD VSS
.ends

* Black-box entry subcircuit for sg13g2_nor2b_1 abstract view
.subckt sg13g2_nor2b_1 A B_N Y VDD VSS
.ends

* Black-box entry subcircuit for sg13g2_and3_1 abstract view
.subckt sg13g2_and3_1 X A B C VDD VSS
.ends

* Black-box entry subcircuit for sg13g2_nand4_1 abstract view
.subckt sg13g2_nand4_1 B C A Y VDD VSS D
.ends

* Black-box entry subcircuit for sg13g2_or4_1 abstract view
.subckt sg13g2_or4_1 A B C D X VDD VSS
.ends

* Black-box entry subcircuit for sg13g2_inv_2 abstract view
.subckt sg13g2_inv_2 Y A VDD VSS
.ends

* Black-box entry subcircuit for sg13g2_buf_16 abstract view
.subckt sg13g2_buf_16 X A VDD VSS
.ends

* Black-box entry subcircuit for sg13g2_and4_1 abstract view
.subckt sg13g2_and4_1 A B C D X VDD VSS
.ends

* Black-box entry subcircuit for sg13g2_inv_4 abstract view
.subckt sg13g2_inv_4 A Y VDD VSS
.ends

* Black-box entry subcircuit for sg13g2_antennanp abstract view
.subckt sg13g2_antennanp VDD VSS A
.ends

.subckt ir_recorder_replay_chip_top VDD VSS busy clk error ir_in ir_tx_npn_drive ld0
+ ld1 ld2 ld3 ld4 ld5 ld6 ld7 rec_done record_req rep_done replay_req rst_n slot_sel[0]
+ slot_sel[1] slot_sel[2] uart_tx
XFILLER_39_211 VDD VSS sg13g2_decap_8
XFILLER_67_553 VDD VSS sg13g2_decap_8
XFILLER_28_918 VDD VSS sg13g2_decap_8
XFILLER_82_501 VDD VSS sg13g2_fill_2
XFILLER_82_512 VDD VSS sg13g2_decap_4
X_3155_ _3184_/B VDD _3155_/Y VSS _3179_/B1 _3155_/A2 sg13g2_o21ai_1
XFILLER_95_873 VDD VSS sg13g2_decap_4
XFILLER_94_350 VDD VSS sg13g2_decap_4
XFILLER_39_288 VDD VSS sg13g2_decap_8
XFILLER_82_523 VDD VSS sg13g2_decap_8
X_3086_ _3086_/A0 hold606/X _4856_/D _4510_/D VDD VSS sg13g2_mux2_1
XFILLER_94_383 VDD VSS sg13g2_fill_1
XFILLER_94_372 VDD VSS sg13g2_decap_8
X_4350__376 VDD VSS _4350_/RESET_B sg13g2_tiehi
XFILLER_51_921 VDD VSS sg13g2_decap_4
X_3988_ VSS VDD _3987_/A _4835_/Q _3988_/Y _3987_/Y sg13g2_a21oi_1
XFILLER_22_199 VDD VSS sg13g2_decap_8
XFILLER_50_497 VDD VSS sg13g2_decap_8
X_2939_ _2939_/A0 _3094_/A0 _2955_/S _2939_/X VDD VSS sg13g2_mux2_1
XFILLER_108_216 VDD VSS sg13g2_decap_8
XFILLER_109_728 VDD VSS sg13g2_decap_8
X_4609_ fanout277/X VSS VDD _4609_/D _4609_/Q _4619_/CLK sg13g2_dfrbpq_1
XFILLER_104_400 VDD VSS sg13g2_decap_8
XFILLER_78_818 VDD VSS sg13g2_fill_2
XFILLER_58_520 VDD VSS sg13g2_decap_8
Xhold1040 _4366_/Q VDD VSS _2936_/A0 sg13g2_dlygate4sd3_1
Xhold1051 _3129_/Y VDD VSS _4552_/D sg13g2_dlygate4sd3_1
XFILLER_93_14 VDD VSS sg13g2_decap_4
XFILLER_86_862 VDD VSS sg13g2_decap_8
XFILLER_45_203 VDD VSS sg13g2_decap_4
XFILLER_45_214 VDD VSS sg13g2_fill_2
XFILLER_45_225 VDD VSS sg13g2_decap_8
XFILLER_46_748 VDD VSS sg13g2_decap_8
XFILLER_73_534 VDD VSS sg13g2_decap_4
XFILLER_85_394 VDD VSS sg13g2_decap_8
Xhold1062 _4707_/Q VDD VSS _3545_/A0 sg13g2_dlygate4sd3_1
Xhold1073 _4387_/Q VDD VSS _2958_/A0 sg13g2_dlygate4sd3_1
Xhold1084 _2886_/X VDD VSS _4319_/D sg13g2_dlygate4sd3_1
Xhold1095 _2829_/X VDD VSS _4266_/D sg13g2_dlygate4sd3_1
XFILLER_26_450 VDD VSS sg13g2_decap_8
XFILLER_53_291 VDD VSS sg13g2_decap_4
XFILLER_42_51 VDD VSS sg13g2_decap_8
XFILLER_10_895 VDD VSS sg13g2_decap_8
XFILLER_6_833 VDD VSS sg13g2_decap_8
XFILLER_5_365 VDD VSS sg13g2_fill_1
XFILLER_107_260 VDD VSS sg13g2_decap_8
XFILLER_108_794 VDD VSS sg13g2_decap_8
XFILLER_69_818 VDD VSS sg13g2_decap_8
XFILLER_96_604 VDD VSS sg13g2_decap_8
XFILLER_96_615 VDD VSS sg13g2_fill_2
XFILLER_95_103 VDD VSS sg13g2_fill_1
XFILLER_110_447 VDD VSS sg13g2_decap_8
XFILLER_68_339 VDD VSS sg13g2_decap_8
XFILLER_49_553 VDD VSS sg13g2_decap_4
XFILLER_67_70 VDD VSS sg13g2_decap_8
XFILLER_37_737 VDD VSS sg13g2_decap_8
XFILLER_37_748 VDD VSS sg13g2_fill_2
XFILLER_37_759 VDD VSS sg13g2_decap_8
XFILLER_64_534 VDD VSS sg13g2_decap_8
XFILLER_76_394 VDD VSS sg13g2_decap_8
XFILLER_52_707 VDD VSS sg13g2_decap_8
X_4960_ fanout296/X VSS VDD _4960_/D _4960_/Q _4960_/CLK sg13g2_dfrbpq_1
XFILLER_91_375 VDD VSS sg13g2_decap_8
XFILLER_44_280 VDD VSS sg13g2_fill_2
X_4891_ fanout310/X VSS VDD _4891_/D _4891_/Q _4894_/CLK sg13g2_dfrbpq_1
X_3911_ _3912_/B _3911_/B _3919_/C VDD VSS sg13g2_nand2b_1
XFILLER_60_762 VDD VSS sg13g2_decap_8
X_3842_ _3842_/Y _3848_/A _3842_/B VDD VSS sg13g2_nand2_1
XFILLER_20_648 VDD VSS sg13g2_decap_8
XFILLER_32_486 VDD VSS sg13g2_decap_8
X_3773_ _3788_/B _3841_/A _3772_/Y _4769_/D VDD VSS sg13g2_a21o_1
XFILLER_66_0 VDD VSS sg13g2_decap_8
X_2724_ _2730_/A _2724_/B _2727_/B VDD VSS sg13g2_and2_1
X_2655_ VSS VDD _2656_/B _2655_/B _2655_/A sg13g2_or2_1
XFILLER_105_219 VDD VSS sg13g2_fill_1
XFILLER_114_742 VDD VSS sg13g2_decap_8
X_4325_ _4325_/RESET_B VSS VDD _4325_/D _4325_/Q _4966_/CLK sg13g2_dfrbpq_1
X_2586_ VDD _3189_/B _3145_/B VSS sg13g2_inv_1
Xfanout105 fanout108/X _2874_/S VDD VSS sg13g2_buf_1
Xfanout116 _3550_/S _3552_/S VDD VSS sg13g2_buf_1
Xfanout127 _3084_/S _3083_/S VDD VSS sg13g2_buf_1
Xfanout138 _4188_/A1 _4241_/A1 VDD VSS sg13g2_buf_1
Xfanout149 _3110_/S _3104_/S VDD VSS sg13g2_buf_1
X_4256_ _4255_/Y VDD _4256_/Y VSS _4253_/Y _4254_/Y sg13g2_o21ai_1
XFILLER_101_458 VDD VSS sg13g2_fill_1
XFILLER_28_704 VDD VSS sg13g2_decap_4
X_4187_ _4187_/A _4378_/Q _4187_/Y VDD VSS sg13g2_nor2_1
X_3207_ _2645_/A VDD _4587_/D VSS _3193_/B _3206_/Y sg13g2_o21ai_1
XFILLER_86_169 VDD VSS sg13g2_fill_1
XFILLER_86_158 VDD VSS sg13g2_decap_4
XFILLER_28_737 VDD VSS sg13g2_decap_4
X_3138_ _3138_/Y _3138_/A _3138_/B VDD VSS sg13g2_nand2_1
XFILLER_94_180 VDD VSS sg13g2_decap_8
XFILLER_103_35 VDD VSS sg13g2_decap_4
XFILLER_43_707 VDD VSS sg13g2_decap_8
XFILLER_83_865 VDD VSS sg13g2_decap_8
XFILLER_36_781 VDD VSS sg13g2_decap_8
XFILLER_55_589 VDD VSS sg13g2_decap_8
XFILLER_63_28 VDD VSS sg13g2_decap_8
X_3069_ _4109_/B _3069_/A1 _3085_/S _4494_/D VDD VSS sg13g2_mux2_1
XFILLER_35_280 VDD VSS sg13g2_decap_8
XFILLER_70_548 VDD VSS sg13g2_decap_8
XFILLER_70_559 VDD VSS sg13g2_fill_2
XFILLER_23_475 VDD VSS sg13g2_decap_4
XFILLER_51_762 VDD VSS sg13g2_decap_8
XFILLER_51_773 VDD VSS sg13g2_fill_2
XFILLER_51_795 VDD VSS sg13g2_fill_1
XFILLER_10_136 VDD VSS sg13g2_decap_8
XFILLER_12_21 VDD VSS sg13g2_decap_8
XFILLER_7_619 VDD VSS sg13g2_decap_8
XFILLER_109_536 VDD VSS sg13g2_decap_8
XFILLER_2_302 VDD VSS sg13g2_decap_8
XFILLER_3_814 VDD VSS sg13g2_decap_8
XFILLER_88_14 VDD VSS sg13g2_decap_8
XFILLER_104_274 VDD VSS sg13g2_fill_2
XFILLER_19_704 VDD VSS sg13g2_decap_8
XFILLER_93_629 VDD VSS sg13g2_decap_8
XFILLER_74_821 VDD VSS sg13g2_decap_8
XFILLER_74_832 VDD VSS sg13g2_fill_2
XFILLER_74_843 VDD VSS sg13g2_decap_8
XFILLER_92_117 VDD VSS sg13g2_decap_8
XFILLER_37_84 VDD VSS sg13g2_decap_4
XFILLER_46_545 VDD VSS sg13g2_decap_8
XFILLER_46_556 VDD VSS sg13g2_fill_2
XFILLER_27_781 VDD VSS sg13g2_decap_8
X_4333__393 VDD VSS _4333_/RESET_B sg13g2_tiehi
XFILLER_33_228 VDD VSS sg13g2_decap_8
XFILLER_61_548 VDD VSS sg13g2_decap_8
XFILLER_53_61 VDD VSS sg13g2_decap_8
XFILLER_53_72 VDD VSS sg13g2_fill_1
XFILLER_6_641 VDD VSS sg13g2_decap_8
XFILLER_108_580 VDD VSS sg13g2_decap_8
X_4340__386 VDD VSS _4340_/RESET_B sg13g2_tiehi
X_2440_ _2440_/B _2809_/A _2440_/Y VDD VSS _2433_/Y sg13g2_nand3b_1
X_2371_ _2370_/Y VDD _2371_/Y VSS _4666_/Q _4658_/Q sg13g2_o21ai_1
XFILLER_97_924 VDD VSS sg13g2_fill_2
XFILLER_96_412 VDD VSS sg13g2_decap_8
XFILLER_69_648 VDD VSS sg13g2_decap_8
X_4110_ _4109_/Y VDD _4110_/Y VSS _4107_/Y _4108_/Y sg13g2_o21ai_1
X_4041_ VSS VDD _4225_/A1 _4037_/X _4041_/Y _4040_/Y sg13g2_a21oi_1
XFILLER_37_534 VDD VSS sg13g2_decap_8
XFILLER_49_361 VDD VSS sg13g2_fill_1
XFILLER_65_876 VDD VSS sg13g2_decap_8
XFILLER_92_662 VDD VSS sg13g2_decap_8
XFILLER_24_217 VDD VSS sg13g2_fill_1
XFILLER_52_526 VDD VSS sg13g2_decap_8
XFILLER_64_386 VDD VSS sg13g2_decap_8
XFILLER_80_813 VDD VSS sg13g2_decap_8
XFILLER_91_150 VDD VSS sg13g2_decap_8
XFILLER_52_559 VDD VSS sg13g2_decap_8
X_4943_ fanout279/X VSS VDD _4943_/D _4943_/Q _4954_/CLK sg13g2_dfrbpq_1
XFILLER_20_412 VDD VSS sg13g2_decap_8
XFILLER_21_924 VDD VSS sg13g2_fill_2
XFILLER_32_283 VDD VSS sg13g2_decap_4
X_4874_ fanout304/X VSS VDD _4874_/D _4874_/Q _4877_/CLK sg13g2_dfrbpq_1
XFILLER_20_456 VDD VSS sg13g2_decap_8
X_3825_ _3825_/Y _3837_/B1 _3824_/Y _3828_/A2 _3385_/A VDD VSS sg13g2_a22oi_1
Xclkbuf_4_12_0_clk clkbuf_0_clk/X clkbuf_4_12_0_clk/X VDD VSS sg13g2_buf_8
X_3756_ _3756_/Y _3829_/A _3764_/D VDD VSS sg13g2_xnor2_1
X_2707_ _4863_/D _2707_/A _2707_/B VDD VSS sg13g2_nand2_1
X_3687_ _3687_/B _3694_/C _3697_/A _3688_/C VDD VSS sg13g2_nand3_1
X_2638_ _2236_/Y _2638_/A1 _4121_/A _4846_/D VDD VSS sg13g2_a21o_1
XFILLER_114_561 VDD VSS sg13g2_fill_2
X_2569_ _2569_/B _2571_/A _2569_/X VDD VSS sg13g2_xor2_1
XFILLER_101_200 VDD VSS sg13g2_decap_8
XFILLER_102_756 VDD VSS sg13g2_decap_8
X_4308_ _4308_/RESET_B VSS VDD _4308_/D _4308_/Q _4397_/CLK sg13g2_dfrbpq_1
X_4239_ _4240_/A _4284_/Q _4309_/Q _4334_/Q _4359_/Q _4241_/B1 _4239_/X VDD VSS sg13g2_mux4_1
XFILLER_28_512 VDD VSS sg13g2_fill_2
XFILLER_74_106 VDD VSS sg13g2_decap_8
XFILLER_56_865 VDD VSS sg13g2_decap_8
XFILLER_28_578 VDD VSS sg13g2_decap_8
XFILLER_43_515 VDD VSS sg13g2_decap_8
XFILLER_43_526 VDD VSS sg13g2_fill_2
XFILLER_55_386 VDD VSS sg13g2_decap_8
XFILLER_82_150 VDD VSS sg13g2_decap_8
XFILLER_83_684 VDD VSS sg13g2_fill_2
XFILLER_15_239 VDD VSS sg13g2_decap_8
XFILLER_43_537 VDD VSS sg13g2_fill_1
XFILLER_12_902 VDD VSS sg13g2_decap_8
XFILLER_23_250 VDD VSS sg13g2_decap_8
XFILLER_24_751 VDD VSS sg13g2_decap_8
XFILLER_70_367 VDD VSS sg13g2_decap_8
XFILLER_51_581 VDD VSS sg13g2_decap_8
XFILLER_90_48 VDD VSS sg13g2_fill_2
XFILLER_23_53 VDD VSS sg13g2_fill_2
XFILLER_11_489 VDD VSS sg13g2_decap_4
XFILLER_7_438 VDD VSS sg13g2_decap_4
XFILLER_109_366 VDD VSS sg13g2_decap_8
XFILLER_79_902 VDD VSS sg13g2_fill_2
XFILLER_3_688 VDD VSS sg13g2_decap_8
XFILLER_79_913 VDD VSS sg13g2_decap_8
XFILLER_79_924 VDD VSS sg13g2_fill_2
XFILLER_97_209 VDD VSS sg13g2_decap_8
XFILLER_47_832 VDD VSS sg13g2_decap_4
XFILLER_59_692 VDD VSS sg13g2_fill_1
XFILLER_65_128 VDD VSS sg13g2_decap_8
XFILLER_93_437 VDD VSS sg13g2_decap_8
XFILLER_0_35 VDD VSS sg13g2_decap_8
XFILLER_19_556 VDD VSS sg13g2_decap_8
XFILLER_47_865 VDD VSS sg13g2_decap_8
XFILLER_46_353 VDD VSS sg13g2_decap_4
XFILLER_61_301 VDD VSS sg13g2_decap_8
XFILLER_73_150 VDD VSS sg13g2_fill_2
XFILLER_73_194 VDD VSS sg13g2_decap_4
XFILLER_61_378 VDD VSS sg13g2_decap_8
XFILLER_62_879 VDD VSS sg13g2_decap_8
XFILLER_30_765 VDD VSS sg13g2_decap_4
XFILLER_9_55 VDD VSS sg13g2_decap_8
XFILLER_30_787 VDD VSS sg13g2_decap_8
XFILLER_80_70 VDD VSS sg13g2_decap_8
X_4590_ fanout281/X VSS VDD _4590_/D _4590_/Q _4946_/CLK sg13g2_dfrbpq_1
X_3610_ _3610_/Y _3612_/A _3610_/B VDD VSS sg13g2_nand2_1
X_3541_ _4703_/Q hold784/X _3550_/S _3541_/X VDD VSS sg13g2_mux2_1
XFILLER_115_303 VDD VSS sg13g2_decap_8
Xhold928 _4353_/Q VDD VSS hold928/X sg13g2_dlygate4sd3_1
Xhold917 _4445_/Q VDD VSS hold917/X sg13g2_dlygate4sd3_1
Xhold906 _4469_/Q VDD VSS hold906/X sg13g2_dlygate4sd3_1
XFILLER_115_358 VDD VSS sg13g2_decap_4
XFILLER_116_859 VDD VSS sg13g2_decap_8
XFILLER_6_482 VDD VSS sg13g2_decap_8
Xhold939 _4340_/Q VDD VSS hold939/X sg13g2_dlygate4sd3_1
X_3472_ _3471_/Y VDD _4673_/D VSS _2290_/Y _3453_/C sg13g2_o21ai_1
X_4418__508 VDD VSS _4418_/RESET_B sg13g2_tiehi
X_2423_ VSS VDD _2357_/A _2422_/Y _2423_/Y _2813_/A sg13g2_a21oi_1
X_2354_ VDD _2453_/C _2354_/A VSS sg13g2_inv_1
XFILLER_96_220 VDD VSS sg13g2_decap_8
XFILLER_111_542 VDD VSS sg13g2_decap_4
XFILLER_29_0 VDD VSS sg13g2_decap_8
Xhold1606 _4765_/Q VDD VSS _3829_/A sg13g2_dlygate4sd3_1
Xhold1617 _4721_/Q VDD VSS _3584_/A sg13g2_dlygate4sd3_1
XFILLER_111_597 VDD VSS sg13g2_fill_2
XFILLER_69_489 VDD VSS sg13g2_decap_8
Xhold1628 _4900_/Q VDD VSS _3789_/A sg13g2_dlygate4sd3_1
Xhold1639 _4789_/Q VDD VSS _2311_/A sg13g2_dlygate4sd3_1
X_2285_ VDD _2285_/Y _3481_/A VSS sg13g2_inv_1
XFILLER_65_640 VDD VSS sg13g2_decap_8
XFILLER_84_459 VDD VSS sg13g2_decap_8
X_4024_ _4052_/A _4262_/Q _4287_/Q _4312_/Q _4337_/Q _4226_/S1 _4024_/X VDD VSS sg13g2_mux4_1
XFILLER_53_802 VDD VSS sg13g2_decap_8
XFILLER_65_684 VDD VSS sg13g2_fill_1
XFILLER_100_14 VDD VSS sg13g2_decap_8
X_4926_ fanout264/X VSS VDD _4926_/D _4926_/Q _4926_/CLK sg13g2_dfrbpq_1
X_4857_ fanout280/X VSS VDD _4857_/D _4857_/Q _4942_/CLK sg13g2_dfrbpq_1
XFILLER_21_798 VDD VSS sg13g2_decap_8
X_3808_ _3808_/Y _3806_/Y _3837_/B1 _3837_/A2 _2324_/Y VDD VSS sg13g2_a22oi_1
XFILLER_20_286 VDD VSS sg13g2_decap_8
X_4788_ fanout248/X VSS VDD _4788_/D _4788_/Q clkload2/A sg13g2_dfrbpq_1
X_3739_ _3739_/Y _3740_/A _3758_/B VDD VSS sg13g2_nand2_1
XFILLER_109_78 VDD VSS sg13g2_decap_8
XFILLER_115_870 VDD VSS sg13g2_decap_8
XFILLER_79_209 VDD VSS sg13g2_decap_8
XFILLER_88_732 VDD VSS sg13g2_decap_8
XFILLER_0_669 VDD VSS sg13g2_decap_8
XFILLER_102_542 VDD VSS sg13g2_decap_8
XFILLER_88_787 VDD VSS sg13g2_decap_8
XFILLER_87_231 VDD VSS sg13g2_decap_8
XFILLER_85_59 VDD VSS sg13g2_decap_8
XFILLER_18_42 VDD VSS sg13g2_decap_8
XFILLER_29_854 VDD VSS sg13g2_decap_8
XFILLER_75_448 VDD VSS sg13g2_decap_8
XFILLER_43_301 VDD VSS sg13g2_decap_8
XFILLER_71_610 VDD VSS sg13g2_decap_8
XFILLER_44_846 VDD VSS sg13g2_decap_8
XFILLER_71_632 VDD VSS sg13g2_fill_1
XFILLER_16_559 VDD VSS sg13g2_decap_4
XFILLER_70_142 VDD VSS sg13g2_decap_8
X_4330__396 VDD VSS _4330_/RESET_B sg13g2_tiehi
XFILLER_31_529 VDD VSS sg13g2_decap_8
XFILLER_43_389 VDD VSS sg13g2_decap_8
XFILLER_12_765 VDD VSS sg13g2_fill_1
XFILLER_11_242 VDD VSS sg13g2_decap_8
XFILLER_11_275 VDD VSS sg13g2_decap_8
XFILLER_7_202 VDD VSS sg13g2_decap_8
XFILLER_113_807 VDD VSS sg13g2_decap_4
XFILLER_98_518 VDD VSS sg13g2_decap_8
XFILLER_106_881 VDD VSS sg13g2_decap_8
XFILLER_59_71 VDD VSS sg13g2_fill_1
XFILLER_22_7 VDD VSS sg13g2_fill_1
XFILLER_94_702 VDD VSS sg13g2_decap_8
XFILLER_78_264 VDD VSS sg13g2_decap_8
XFILLER_78_275 VDD VSS sg13g2_fill_2
XFILLER_66_448 VDD VSS sg13g2_decap_4
XFILLER_94_779 VDD VSS sg13g2_decap_8
XFILLER_93_245 VDD VSS sg13g2_decap_8
XFILLER_46_183 VDD VSS sg13g2_decap_8
XFILLER_35_868 VDD VSS sg13g2_decap_8
XFILLER_61_186 VDD VSS sg13g2_decap_8
X_2972_ _2972_/A0 _3101_/A0 _2975_/S _4401_/D VDD VSS sg13g2_mux2_1
X_4711_ fanout322/X VSS VDD _4711_/D _4711_/Q _4979_/CLK sg13g2_dfrbpq_1
XFILLER_91_80 VDD VSS sg13g2_fill_1
X_4642_ fanout268/X VSS VDD _4642_/D _4642_/Q _4745_/CLK sg13g2_dfrbpq_1
Xhold703 _3704_/Y VDD VSS _4752_/D sg13g2_dlygate4sd3_1
X_4573_ fanout333/X VSS VDD _4573_/D _4573_/Q _4580_/CLK sg13g2_dfrbpq_1
Xhold736 _4678_/Q VDD VSS _3479_/A sg13g2_dlygate4sd3_1
Xhold725 _3265_/Y VDD VSS hold725/X sg13g2_dlygate4sd3_1
Xhold714 _4722_/Q VDD VSS _3587_/C sg13g2_dlygate4sd3_1
X_3524_ _3556_/B _3524_/A _3596_/B VDD VSS sg13g2_nand2_1
XFILLER_115_144 VDD VSS sg13g2_fill_1
XFILLER_116_667 VDD VSS sg13g2_fill_2
Xhold769 _4777_/Q VDD VSS _2327_/A sg13g2_dlygate4sd3_1
Xhold758 _4961_/Q VDD VSS _4079_/B sg13g2_dlygate4sd3_1
Xhold747 _2421_/X VDD VSS _4925_/D sg13g2_dlygate4sd3_1
X_3455_ _3473_/B _3475_/C _3455_/A _3455_/Y VDD VSS sg13g2_nand3_1
X_2406_ _2800_/A _2406_/B _2431_/C VDD VSS sg13g2_and2_1
XFILLER_69_242 VDD VSS sg13g2_decap_4
X_3386_ _3329_/A VDD _3386_/Y VSS _4785_/Q _3385_/Y sg13g2_o21ai_1
XFILLER_97_562 VDD VSS sg13g2_fill_1
XFILLER_84_201 VDD VSS sg13g2_fill_2
Xhold1403 _4654_/Q VDD VSS _3431_/A sg13g2_dlygate4sd3_1
Xhold1414 _2438_/Y VDD VSS _4915_/D sg13g2_dlygate4sd3_1
Xhold1425 _3591_/Y VDD VSS _3593_/B sg13g2_dlygate4sd3_1
X_2337_ VDD _2337_/Y _2634_/A VSS sg13g2_inv_1
XFILLER_97_595 VDD VSS sg13g2_decap_8
XFILLER_85_713 VDD VSS sg13g2_decap_8
XFILLER_84_245 VDD VSS sg13g2_decap_8
Xhold1436 _3738_/Y VDD VSS _4759_/D sg13g2_dlygate4sd3_1
Xhold1447 _3624_/X VDD VSS _4736_/D sg13g2_dlygate4sd3_1
Xhold1458 _4732_/Q VDD VSS _3620_/A0 sg13g2_dlygate4sd3_1
X_2268_ VDD _2268_/Y _4654_/Q VSS sg13g2_inv_1
Xhold1469 _3653_/X VDD VSS _4748_/D sg13g2_dlygate4sd3_1
X_4007_ VDD VSS _4842_/Q _4006_/Y _4831_/Q _4006_/B _4007_/Y _3981_/A sg13g2_a221oi_1
XFILLER_25_334 VDD VSS sg13g2_fill_1
XFILLER_93_790 VDD VSS sg13g2_fill_2
XFILLER_111_35 VDD VSS sg13g2_decap_4
XFILLER_37_194 VDD VSS sg13g2_decap_8
XFILLER_80_451 VDD VSS sg13g2_decap_8
XFILLER_13_529 VDD VSS sg13g2_fill_2
XFILLER_40_348 VDD VSS sg13g2_decap_8
X_4909_ fanout258/X VSS VDD _4909_/D _4909_/Q clkload7/A sg13g2_dfrbpq_1
XFILLER_21_584 VDD VSS sg13g2_decap_8
XFILLER_5_739 VDD VSS sg13g2_decap_8
XFILLER_107_634 VDD VSS sg13g2_decap_8
XFILLER_107_645 VDD VSS sg13g2_fill_2
XFILLER_20_21 VDD VSS sg13g2_decap_8
XFILLER_1_901 VDD VSS sg13g2_decap_8
XFILLER_20_76 VDD VSS sg13g2_decap_8
XFILLER_96_14 VDD VSS sg13g2_decap_8
XFILLER_88_551 VDD VSS sg13g2_decap_8
XFILLER_0_466 VDD VSS sg13g2_decap_8
XFILLER_29_74 VDD VSS sg13g2_decap_8
XFILLER_48_448 VDD VSS sg13g2_decap_8
XFILLER_29_673 VDD VSS sg13g2_decap_8
XFILLER_90_204 VDD VSS sg13g2_decap_8
XFILLER_17_846 VDD VSS sg13g2_decap_8
XFILLER_28_161 VDD VSS sg13g2_fill_2
XFILLER_28_183 VDD VSS sg13g2_decap_4
XFILLER_44_610 VDD VSS sg13g2_decap_8
XFILLER_90_248 VDD VSS sg13g2_decap_8
XFILLER_43_153 VDD VSS sg13g2_decap_8
XFILLER_44_687 VDD VSS sg13g2_decap_8
XFILLER_31_337 VDD VSS sg13g2_decap_8
X_4408__518 VDD VSS _4408_/RESET_B sg13g2_tiehi
XFILLER_12_551 VDD VSS sg13g2_fill_2
XFILLER_40_871 VDD VSS sg13g2_decap_8
XFILLER_8_522 VDD VSS sg13g2_decap_8
XFILLER_12_584 VDD VSS sg13g2_decap_8
XFILLER_12_595 VDD VSS sg13g2_fill_2
XFILLER_8_577 VDD VSS sg13g2_decap_8
XFILLER_6_78 VDD VSS sg13g2_decap_8
XFILLER_112_114 VDD VSS sg13g2_fill_1
XFILLER_113_659 VDD VSS sg13g2_fill_1
X_3240_ _3240_/Y _3242_/B _3244_/A VDD VSS sg13g2_nand2b_1
XFILLER_79_562 VDD VSS sg13g2_decap_8
X_3171_ _2510_/B VDD _3171_/Y VSS _3169_/A _3169_/B sg13g2_o21ai_1
XFILLER_86_80 VDD VSS sg13g2_decap_8
XFILLER_26_109 VDD VSS sg13g2_fill_2
XFILLER_54_418 VDD VSS sg13g2_decap_8
XFILLER_66_256 VDD VSS sg13g2_decap_4
XFILLER_67_779 VDD VSS sg13g2_decap_8
XFILLER_81_204 VDD VSS sg13g2_fill_2
XFILLER_19_172 VDD VSS sg13g2_decap_8
XFILLER_47_481 VDD VSS sg13g2_decap_8
XFILLER_35_643 VDD VSS sg13g2_decap_8
XFILLER_62_451 VDD VSS sg13g2_decap_4
XFILLER_34_175 VDD VSS sg13g2_decap_8
XFILLER_50_646 VDD VSS sg13g2_decap_8
XFILLER_96_0 VDD VSS sg13g2_decap_8
XFILLER_31_860 VDD VSS sg13g2_decap_8
XFILLER_31_871 VDD VSS sg13g2_fill_1
X_2955_ hold867/X _3110_/A0 _2955_/S _2955_/X VDD VSS sg13g2_mux2_1
X_2886_ _2886_/A0 _3094_/A0 _2896_/S _2886_/X VDD VSS sg13g2_mux2_1
X_4625_ fanout285/X VSS VDD _4625_/D _4625_/Q _4658_/CLK sg13g2_dfrbpq_1
X_4556_ fanout266/X VSS VDD _4556_/D _4556_/Q clkload8/A sg13g2_dfrbpq_1
Xhold544 _4928_/Q VDD VSS _3293_/B sg13g2_dlygate4sd3_1
X_3507_ _3513_/B _3507_/B _3509_/A VDD VSS sg13g2_nor2_1
Xhold555 _4898_/Q VDD VSS _4257_/A sg13g2_dlygate4sd3_1
Xhold566 _4943_/Q VDD VSS _2730_/A sg13g2_dlygate4sd3_1
Xhold577 _3135_/Y VDD VSS _4555_/D sg13g2_dlygate4sd3_1
Xhold588 _4553_/Q VDD VSS _3130_/A sg13g2_dlygate4sd3_1
X_4487_ fanout307/X VSS VDD _4487_/D _4487_/Q _4967_/CLK sg13g2_dfrbpq_1
Xhold599 _4837_/Q VDD VSS _4001_/A sg13g2_dlygate4sd3_1
X_3438_ _3437_/Y VDD _3438_/Y VSS _2272_/Y _3471_/C sg13g2_o21ai_1
XFILLER_89_359 VDD VSS sg13g2_decap_8
Xhold1200 _4295_/Q VDD VSS _2860_/A0 sg13g2_dlygate4sd3_1
X_3369_ _3469_/A _3369_/A1 _3369_/S _4645_/D VDD VSS sg13g2_mux2_1
XFILLER_98_871 VDD VSS sg13g2_decap_8
XFILLER_100_854 VDD VSS sg13g2_decap_8
XFILLER_66_28 VDD VSS sg13g2_decap_8
Xhold1211 _4357_/Q VDD VSS _2925_/A0 sg13g2_dlygate4sd3_1
Xhold1222 _4518_/Q VDD VSS hold1222/X sg13g2_dlygate4sd3_1
Xhold1233 _3922_/Y VDD VSS _3923_/B sg13g2_dlygate4sd3_1
XFILLER_97_392 VDD VSS sg13g2_decap_8
XFILLER_85_554 VDD VSS sg13g2_decap_8
Xhold1244 _4573_/Q VDD VSS _3174_/A sg13g2_dlygate4sd3_1
Xhold1255 _4681_/Q VDD VSS _3485_/A sg13g2_dlygate4sd3_1
Xhold1266 _4275_/Q VDD VSS _2838_/A0 sg13g2_dlygate4sd3_1
Xhold1277 _2848_/X VDD VSS _4285_/D sg13g2_dlygate4sd3_1
Xhold1288 _3125_/X VDD VSS _4549_/D sg13g2_dlygate4sd3_1
Xhold1299 _4503_/Q VDD VSS _3079_/A1 sg13g2_dlygate4sd3_1
XFILLER_14_805 VDD VSS sg13g2_decap_8
XFILLER_25_142 VDD VSS sg13g2_decap_8
XFILLER_53_451 VDD VSS sg13g2_fill_2
XFILLER_25_164 VDD VSS sg13g2_decap_8
XFILLER_53_473 VDD VSS sg13g2_decap_8
XFILLER_13_348 VDD VSS sg13g2_decap_8
XFILLER_40_123 VDD VSS sg13g2_decap_8
XFILLER_15_87 VDD VSS sg13g2_decap_8
XFILLER_40_167 VDD VSS sg13g2_decap_8
XFILLER_9_308 VDD VSS sg13g2_decap_8
XFILLER_31_42 VDD VSS sg13g2_decap_8
XFILLER_107_464 VDD VSS sg13g2_decap_8
Xoutput20 _4932_/Q rep_done VDD VSS sg13g2_buf_1
XFILLER_96_819 VDD VSS sg13g2_decap_4
XFILLER_0_252 VDD VSS sg13g2_decap_8
XFILLER_103_670 VDD VSS sg13g2_fill_1
XFILLER_1_775 VDD VSS sg13g2_decap_8
XFILLER_49_702 VDD VSS sg13g2_decap_8
XFILLER_95_307 VDD VSS sg13g2_decap_8
XFILLER_89_882 VDD VSS sg13g2_fill_1
XFILLER_37_908 VDD VSS sg13g2_decap_8
XFILLER_48_223 VDD VSS sg13g2_decap_8
XFILLER_91_568 VDD VSS sg13g2_decap_8
XFILLER_44_484 VDD VSS sg13g2_decap_8
XFILLER_60_922 VDD VSS sg13g2_decap_4
XFILLER_31_112 VDD VSS sg13g2_decap_8
XFILLER_31_123 VDD VSS sg13g2_fill_1
XFILLER_31_156 VDD VSS sg13g2_decap_8
XFILLER_12_370 VDD VSS sg13g2_decap_4
XFILLER_13_882 VDD VSS sg13g2_decap_8
X_2740_ _2740_/Y _2742_/B hold1522/X VDD VSS sg13g2_nand2b_1
XFILLER_9_842 VDD VSS sg13g2_decap_8
X_2671_ VSS VDD _2666_/Y _2667_/Y _2671_/Y _3511_/A sg13g2_a21oi_1
X_4410_ _4410_/RESET_B VSS VDD _4410_/D _4410_/Q _4961_/CLK sg13g2_dfrbpq_1
XFILLER_114_913 VDD VSS sg13g2_decap_8
XFILLER_114_924 VDD VSS sg13g2_fill_2
X_4341_ _4341_/RESET_B VSS VDD _4341_/D _4341_/Q clkload6/A sg13g2_dfrbpq_1
XFILLER_99_635 VDD VSS sg13g2_decap_8
Xfanout309 fanout310/X fanout309/X VDD VSS sg13g2_buf_1
X_4272_ _4272_/RESET_B VSS VDD _4272_/D _4272_/Q _4397_/CLK sg13g2_dfrbpq_1
XFILLER_98_134 VDD VSS sg13g2_decap_8
X_3223_ _3230_/A _3223_/B _4594_/D VDD VSS sg13g2_nor2_1
XFILLER_79_381 VDD VSS sg13g2_decap_8
XFILLER_95_852 VDD VSS sg13g2_decap_8
XFILLER_11_0 VDD VSS sg13g2_decap_8
XFILLER_39_267 VDD VSS sg13g2_decap_8
X_3154_ _3154_/B _3154_/A _3154_/X VDD VSS sg13g2_xor2_1
XFILLER_94_340 VDD VSS sg13g2_fill_1
XFILLER_55_749 VDD VSS sg13g2_decap_8
X_3085_ _4255_/B hold794/X _3085_/S _4509_/D VDD VSS sg13g2_mux2_1
XFILLER_23_624 VDD VSS sg13g2_decap_8
XFILLER_63_771 VDD VSS sg13g2_fill_2
XFILLER_22_123 VDD VSS sg13g2_decap_8
XFILLER_22_156 VDD VSS sg13g2_decap_4
XFILLER_23_679 VDD VSS sg13g2_decap_8
X_3987_ _3987_/A _3987_/B _3987_/Y VDD VSS sg13g2_nor2_1
XFILLER_10_329 VDD VSS sg13g2_fill_2
XFILLER_22_178 VDD VSS sg13g2_decap_8
X_2938_ hold833/X _3017_/A1 _2953_/S _4368_/D VDD VSS sg13g2_mux2_1
XFILLER_109_707 VDD VSS sg13g2_decap_8
X_2869_ _2869_/A0 _3104_/A0 _2869_/S _4304_/D VDD VSS sg13g2_mux2_1
XFILLER_105_913 VDD VSS sg13g2_decap_8
X_4608_ fanout277/X VSS VDD _4608_/D _4608_/Q _4950_/CLK sg13g2_dfrbpq_1
XFILLER_105_924 VDD VSS sg13g2_fill_2
XFILLER_2_528 VDD VSS sg13g2_fill_2
XFILLER_2_539 VDD VSS sg13g2_decap_8
X_4539_ fanout285/X VSS VDD _4539_/D _4539_/Q _4559_/CLK sg13g2_dfrbpq_1
XFILLER_89_112 VDD VSS sg13g2_decap_8
XFILLER_104_478 VDD VSS sg13g2_decap_8
XFILLER_86_841 VDD VSS sg13g2_decap_8
XFILLER_46_716 VDD VSS sg13g2_decap_8
XFILLER_58_565 VDD VSS sg13g2_decap_8
Xhold1030 _4365_/Q VDD VSS _4052_/B sg13g2_dlygate4sd3_1
Xhold1041 _2936_/X VDD VSS _4366_/D sg13g2_dlygate4sd3_1
XFILLER_73_513 VDD VSS sg13g2_decap_8
XFILLER_85_373 VDD VSS sg13g2_decap_8
Xhold1052 _4355_/Q VDD VSS _2923_/A0 sg13g2_dlygate4sd3_1
Xhold1063 _4462_/Q VDD VSS _3547_/A1 sg13g2_dlygate4sd3_1
Xhold1074 _4419_/Q VDD VSS _2992_/A0 sg13g2_dlygate4sd3_1
Xhold1085 _4367_/Q VDD VSS _2937_/A0 sg13g2_dlygate4sd3_1
XFILLER_93_37 VDD VSS sg13g2_decap_8
XFILLER_93_26 VDD VSS sg13g2_fill_2
Xhold1096 _4429_/Q VDD VSS _3002_/A0 sg13g2_dlygate4sd3_1
XFILLER_14_613 VDD VSS sg13g2_fill_2
XFILLER_26_64 VDD VSS sg13g2_fill_1
XFILLER_13_112 VDD VSS sg13g2_decap_8
XFILLER_53_270 VDD VSS sg13g2_decap_8
XFILLER_14_679 VDD VSS sg13g2_decap_8
XFILLER_41_454 VDD VSS sg13g2_fill_2
XFILLER_41_487 VDD VSS sg13g2_decap_4
XFILLER_9_149 VDD VSS sg13g2_decap_8
XFILLER_6_812 VDD VSS sg13g2_decap_8
XFILLER_10_874 VDD VSS sg13g2_decap_8
XFILLER_114_209 VDD VSS sg13g2_decap_8
XFILLER_108_773 VDD VSS sg13g2_decap_8
XFILLER_6_889 VDD VSS sg13g2_decap_8
XFILLER_111_916 VDD VSS sg13g2_decap_8
XFILLER_3_35 VDD VSS sg13g2_decap_8
XFILLER_110_426 VDD VSS sg13g2_decap_8
XFILLER_49_521 VDD VSS sg13g2_fill_2
XFILLER_49_532 VDD VSS sg13g2_fill_2
XFILLER_96_649 VDD VSS sg13g2_decap_8
XFILLER_37_716 VDD VSS sg13g2_decap_8
XFILLER_76_340 VDD VSS sg13g2_decap_8
XFILLER_76_351 VDD VSS sg13g2_fill_2
XFILLER_77_852 VDD VSS sg13g2_fill_1
XFILLER_77_885 VDD VSS sg13g2_decap_4
XFILLER_95_159 VDD VSS sg13g2_fill_1
XFILLER_49_598 VDD VSS sg13g2_decap_8
XFILLER_64_513 VDD VSS sg13g2_decap_8
XFILLER_76_373 VDD VSS sg13g2_decap_8
XFILLER_91_321 VDD VSS sg13g2_decap_8
XFILLER_91_354 VDD VSS sg13g2_decap_8
XFILLER_92_888 VDD VSS sg13g2_decap_4
XFILLER_17_484 VDD VSS sg13g2_fill_1
X_4890_ fanout310/X VSS VDD _4890_/D _4890_/Q _4894_/CLK sg13g2_dfrbpq_1
X_3910_ _3918_/B _3910_/B _3919_/C VDD VSS sg13g2_and2_1
XFILLER_91_398 VDD VSS sg13g2_fill_1
XFILLER_20_605 VDD VSS sg13g2_decap_8
XFILLER_20_616 VDD VSS sg13g2_fill_2
X_3841_ _3841_/B _3841_/A _3842_/B VDD VSS sg13g2_xor2_1
XFILLER_20_627 VDD VSS sg13g2_decap_8
X_3772_ _3786_/B _3779_/C _3772_/C _3772_/Y VDD VSS sg13g2_nor3_1
XFILLER_13_690 VDD VSS sg13g2_decap_8
X_2723_ _2730_/A _2752_/A _4943_/D VDD VSS sg13g2_nor2_1
XFILLER_9_672 VDD VSS sg13g2_decap_4
XFILLER_8_171 VDD VSS sg13g2_decap_4
X_2654_ _3513_/A _3511_/B _2654_/A _2655_/B VDD VSS sg13g2_nand3_1
XFILLER_59_0 VDD VSS sg13g2_decap_8
X_2585_ _4851_/Q _4929_/Q _2585_/Y VDD VSS sg13g2_nor2_1
X_4324_ _4324_/RESET_B VSS VDD _4324_/D _4324_/Q _4968_/CLK sg13g2_dfrbpq_1
Xfanout106 fanout108/X _2875_/S VDD VSS sg13g2_buf_1
Xfanout117 _3553_/S _3550_/S VDD VSS sg13g2_buf_1
Xfanout128 _3082_/S _3084_/S VDD VSS sg13g2_buf_1
Xfanout139 _4188_/A1 _4196_/A1 VDD VSS sg13g2_buf_1
X_4255_ _4255_/Y _4255_/B _4169_/A VDD VSS sg13g2_nand2b_1
XFILLER_86_137 VDD VSS sg13g2_decap_4
X_4186_ _4428_/Q _4453_/Q _4186_/S _4186_/X VDD VSS sg13g2_mux2_1
X_3206_ _3206_/Y _3206_/A _3206_/B VDD VSS sg13g2_xnor2_1
XFILLER_86_148 VDD VSS sg13g2_fill_1
XFILLER_103_14 VDD VSS sg13g2_decap_8
XFILLER_27_215 VDD VSS sg13g2_decap_4
X_3137_ _3136_/Y VDD _3137_/Y VSS _4629_/Q _3136_/B sg13g2_o21ai_1
XFILLER_55_568 VDD VSS sg13g2_decap_8
XFILLER_82_332 VDD VSS sg13g2_fill_2
XFILLER_24_922 VDD VSS sg13g2_decap_4
XFILLER_36_760 VDD VSS sg13g2_decap_4
X_3068_ _3067_/Y VDD _4493_/D VSS _2352_/Y _3085_/S sg13g2_o21ai_1
XFILLER_42_229 VDD VSS sg13g2_decap_8
XFILLER_23_454 VDD VSS sg13g2_decap_8
XFILLER_10_115 VDD VSS sg13g2_decap_8
XFILLER_12_88 VDD VSS sg13g2_fill_2
XFILLER_88_59 VDD VSS sg13g2_decap_8
XFILLER_104_253 VDD VSS sg13g2_decap_8
XFILLER_105_798 VDD VSS sg13g2_decap_8
XFILLER_104_286 VDD VSS sg13g2_fill_1
XFILLER_59_874 VDD VSS sg13g2_decap_8
XFILLER_77_159 VDD VSS sg13g2_decap_8
XFILLER_74_811 VDD VSS sg13g2_fill_2
XFILLER_86_682 VDD VSS sg13g2_decap_8
XFILLER_18_259 VDD VSS sg13g2_fill_1
XFILLER_37_63 VDD VSS sg13g2_decap_8
XFILLER_15_922 VDD VSS sg13g2_decap_4
XFILLER_61_505 VDD VSS sg13g2_decap_8
XFILLER_14_432 VDD VSS sg13g2_decap_8
XFILLER_42_741 VDD VSS sg13g2_decap_4
XFILLER_14_443 VDD VSS sg13g2_decap_8
XFILLER_30_914 VDD VSS sg13g2_decap_8
XFILLER_30_925 VDD VSS sg13g2_fill_1
XFILLER_6_620 VDD VSS sg13g2_decap_8
XFILLER_10_693 VDD VSS sg13g2_fill_2
XFILLER_52_7 VDD VSS sg13g2_decap_8
XFILLER_5_163 VDD VSS sg13g2_decap_8
XFILLER_5_185 VDD VSS sg13g2_fill_1
XFILLER_69_605 VDD VSS sg13g2_decap_4
X_2370_ _2370_/Y _4680_/Q _4672_/Q _4657_/Q _4665_/Q VDD VSS sg13g2_a22oi_1
XFILLER_111_724 VDD VSS sg13g2_decap_8
XFILLER_1_380 VDD VSS sg13g2_decap_8
X_4040_ _4227_/A1 VDD _4040_/Y VSS _4038_/Y _4039_/Y sg13g2_o21ai_1
XFILLER_65_844 VDD VSS sg13g2_decap_8
XFILLER_76_192 VDD VSS sg13g2_decap_8
XFILLER_92_641 VDD VSS sg13g2_decap_8
XFILLER_64_365 VDD VSS sg13g2_decap_4
XFILLER_92_674 VDD VSS sg13g2_decap_8
XFILLER_80_869 VDD VSS sg13g2_decap_8
X_4942_ fanout279/X VSS VDD _4942_/D _4942_/Q _4942_/CLK sg13g2_dfrbpq_1
XFILLER_21_903 VDD VSS sg13g2_decap_8
XFILLER_33_774 VDD VSS sg13g2_decap_8
X_4873_ fanout304/X VSS VDD _4873_/D _4873_/Q _4877_/CLK sg13g2_dfrbpq_1
X_3824_ _3827_/A VDD _3824_/Y VSS _3826_/B _3823_/Y sg13g2_o21ai_1
X_3755_ _3755_/Y _3829_/A _3758_/B VDD VSS sg13g2_nand2_1
XFILLER_9_480 VDD VSS sg13g2_decap_8
XFILLER_106_507 VDD VSS sg13g2_fill_1
X_3686_ _4731_/Q _4730_/Q _3686_/C _3694_/C VDD VSS sg13g2_or3_1
X_2706_ VSS VDD _2256_/Y _2704_/B _2707_/B _3551_/S sg13g2_a21oi_1
X_2637_ VDD _4841_/D _2637_/A VSS sg13g2_inv_1
X_2568_ _2568_/A _2569_/B _2568_/Y VDD VSS sg13g2_nor2_1
XFILLER_99_262 VDD VSS sg13g2_decap_8
XFILLER_102_735 VDD VSS sg13g2_decap_8
XFILLER_59_137 VDD VSS sg13g2_decap_8
X_4307_ _4307_/RESET_B VSS VDD _4307_/D _4307_/Q clkload8/A sg13g2_dfrbpq_1
X_2499_ _3522_/A _2499_/B _4862_/D VDD VSS sg13g2_and2_1
XFILLER_99_273 VDD VSS sg13g2_fill_1
X_4238_ _4237_/Y VDD _4238_/Y VSS _4235_/Y _4236_/Y sg13g2_o21ai_1
XFILLER_114_57 VDD VSS sg13g2_decap_8
XFILLER_28_557 VDD VSS sg13g2_decap_8
XFILLER_56_844 VDD VSS sg13g2_decap_8
X_4169_ _4169_/Y _4169_/A _4169_/B VDD VSS sg13g2_nand2_1
XFILLER_55_365 VDD VSS sg13g2_decap_8
XFILLER_83_663 VDD VSS sg13g2_decap_8
XFILLER_71_858 VDD VSS sg13g2_decap_8
XFILLER_82_184 VDD VSS sg13g2_fill_1
XFILLER_70_346 VDD VSS sg13g2_decap_8
XFILLER_11_424 VDD VSS sg13g2_decap_8
XFILLER_12_925 VDD VSS sg13g2_fill_1
XFILLER_51_560 VDD VSS sg13g2_decap_8
XFILLER_23_295 VDD VSS sg13g2_decap_8
XFILLER_8_918 VDD VSS sg13g2_decap_8
XFILLER_11_468 VDD VSS sg13g2_decap_8
XFILLER_7_417 VDD VSS sg13g2_decap_8
XFILLER_109_345 VDD VSS sg13g2_decap_4
XFILLER_2_144 VDD VSS sg13g2_fill_1
XFILLER_105_595 VDD VSS sg13g2_fill_2
XFILLER_78_468 VDD VSS sg13g2_decap_8
XFILLER_19_513 VDD VSS sg13g2_decap_8
XFILLER_48_73 VDD VSS sg13g2_decap_8
XFILLER_59_660 VDD VSS sg13g2_fill_1
XFILLER_0_14 VDD VSS sg13g2_decap_8
XFILLER_47_844 VDD VSS sg13g2_decap_8
XFILLER_58_192 VDD VSS sg13g2_decap_8
XFILLER_62_814 VDD VSS sg13g2_decap_8
XFILLER_74_674 VDD VSS sg13g2_fill_2
XFILLER_62_858 VDD VSS sg13g2_decap_8
XFILLER_61_357 VDD VSS sg13g2_decap_8
XFILLER_15_774 VDD VSS sg13g2_decap_8
XFILLER_30_744 VDD VSS sg13g2_decap_8
X_3540_ _3540_/A0 _3540_/A1 _3552_/S _4702_/D VDD VSS sg13g2_mux2_1
XFILLER_116_838 VDD VSS sg13g2_decap_8
Xhold918 _3019_/X VDD VSS _4445_/D sg13g2_dlygate4sd3_1
Xhold907 _3530_/X VDD VSS _4692_/D sg13g2_dlygate4sd3_1
Xhold929 _2921_/X VDD VSS _4353_/D sg13g2_dlygate4sd3_1
X_3471_ _3471_/B _3471_/C _3471_/A _3471_/Y VDD VSS sg13g2_nand3_1
X_2422_ _4920_/Q _2422_/C _4921_/Q _2422_/Y VDD VSS sg13g2_nand3_1
XFILLER_111_521 VDD VSS sg13g2_decap_8
X_2353_ VDD _2353_/Y _2353_/A VSS sg13g2_inv_1
Xhold1607 _3755_/Y VDD VSS _3757_/B1 sg13g2_dlygate4sd3_1
XFILLER_85_906 VDD VSS sg13g2_decap_8
XFILLER_111_576 VDD VSS sg13g2_decap_8
XFILLER_84_438 VDD VSS sg13g2_decap_8
Xhold1618 _4780_/Q VDD VSS _2322_/A sg13g2_dlygate4sd3_1
Xhold1629 _4603_/Q VDD VSS _3244_/B sg13g2_dlygate4sd3_1
X_4023_ VSS VDD _4253_/A1 _4019_/X _4023_/Y _4022_/Y sg13g2_a21oi_1
X_2284_ VDD _2284_/Y _3463_/A VSS sg13g2_inv_1
XFILLER_49_192 VDD VSS sg13g2_decap_8
XFILLER_53_825 VDD VSS sg13g2_fill_1
XFILLER_80_600 VDD VSS sg13g2_decap_8
XFILLER_52_313 VDD VSS sg13g2_decap_4
XFILLER_64_173 VDD VSS sg13g2_fill_1
XFILLER_64_184 VDD VSS sg13g2_fill_2
XFILLER_65_696 VDD VSS sg13g2_decap_8
XFILLER_53_869 VDD VSS sg13g2_fill_2
XFILLER_52_379 VDD VSS sg13g2_decap_4
X_4925_ fanout260/X VSS VDD _4925_/D _4925_/Q clkload5/A sg13g2_dfrbpq_1
X_4856_ fanout316/X VSS VDD _4856_/D _4856_/Q _4929_/CLK sg13g2_dfrbpq_1
XFILLER_21_777 VDD VSS sg13g2_decap_8
X_3807_ _3807_/A _3807_/B _3807_/C _3807_/Y VDD VSS sg13g2_nor3_1
X_4787_ fanout250/X VSS VDD _4787_/D _4787_/Q clkload2/A sg13g2_dfrbpq_1
XFILLER_109_35 VDD VSS sg13g2_fill_2
X_3738_ _3735_/Y VDD _3738_/Y VSS _3766_/A1 _3737_/Y sg13g2_o21ai_1
XFILLER_109_57 VDD VSS sg13g2_fill_2
X_3669_ _3718_/B _3717_/A _3688_/A VDD VSS sg13g2_nand2b_1
XFILLER_88_711 VDD VSS sg13g2_fill_2
X_4319__407 VDD VSS _4319_/RESET_B sg13g2_tiehi
XFILLER_0_648 VDD VSS sg13g2_decap_8
XFILLER_76_906 VDD VSS sg13g2_decap_8
XFILLER_75_427 VDD VSS sg13g2_decap_8
XFILLER_18_21 VDD VSS sg13g2_decap_8
XFILLER_29_833 VDD VSS sg13g2_decap_8
XFILLER_87_298 VDD VSS sg13g2_fill_1
XFILLER_44_825 VDD VSS sg13g2_decap_8
XFILLER_16_538 VDD VSS sg13g2_decap_8
XFILLER_56_685 VDD VSS sg13g2_decap_8
XFILLER_31_508 VDD VSS sg13g2_decap_8
XFILLER_70_121 VDD VSS sg13g2_decap_8
XFILLER_34_53 VDD VSS sg13g2_fill_2
XFILLER_11_221 VDD VSS sg13g2_decap_8
XFILLER_8_715 VDD VSS sg13g2_decap_8
XFILLER_109_120 VDD VSS sg13g2_decap_8
XFILLER_12_799 VDD VSS sg13g2_decap_4
XFILLER_50_63 VDD VSS sg13g2_decap_8
XFILLER_4_921 VDD VSS sg13g2_decap_4
XFILLER_50_96 VDD VSS sg13g2_decap_8
XFILLER_106_860 VDD VSS sg13g2_decap_8
XFILLER_3_431 VDD VSS sg13g2_decap_4
XFILLER_105_381 VDD VSS sg13g2_decap_8
XFILLER_112_329 VDD VSS sg13g2_decap_4
XFILLER_3_464 VDD VSS sg13g2_decap_8
XFILLER_3_475 VDD VSS sg13g2_fill_2
XFILLER_105_392 VDD VSS sg13g2_fill_1
XFILLER_39_608 VDD VSS sg13g2_fill_2
XFILLER_59_94 VDD VSS sg13g2_decap_8
XFILLER_67_917 VDD VSS sg13g2_decap_8
XFILLER_78_243 VDD VSS sg13g2_decap_8
XFILLER_66_427 VDD VSS sg13g2_decap_8
XFILLER_79_788 VDD VSS sg13g2_fill_1
XFILLER_15_7 VDD VSS sg13g2_decap_4
XFILLER_19_321 VDD VSS sg13g2_fill_1
Xclkbuf_leaf_58_clk clkbuf_4_2_0_clk/X clkload5/A VDD VSS sg13g2_buf_8
XFILLER_94_758 VDD VSS sg13g2_decap_8
XFILLER_19_354 VDD VSS sg13g2_decap_8
XFILLER_35_814 VDD VSS sg13g2_decap_8
XFILLER_46_151 VDD VSS sg13g2_fill_2
Xclkbuf_4_11_0_clk clkbuf_0_clk/X clkbuf_4_11_0_clk/X VDD VSS sg13g2_buf_8
XFILLER_19_398 VDD VSS sg13g2_decap_8
XFILLER_35_847 VDD VSS sg13g2_decap_8
XFILLER_46_162 VDD VSS sg13g2_decap_8
XFILLER_62_611 VDD VSS sg13g2_decap_8
XFILLER_62_655 VDD VSS sg13g2_decap_4
XFILLER_62_677 VDD VSS sg13g2_fill_2
XFILLER_15_571 VDD VSS sg13g2_decap_8
XFILLER_61_165 VDD VSS sg13g2_decap_8
XFILLER_62_699 VDD VSS sg13g2_decap_8
X_2971_ _2971_/A0 _3100_/A0 _2979_/S _2971_/X VDD VSS sg13g2_mux2_1
XFILLER_30_530 VDD VSS sg13g2_decap_8
XFILLER_42_390 VDD VSS sg13g2_decap_8
X_4710_ fanout311/X VSS VDD _4710_/D _4710_/Q _4869_/CLK sg13g2_dfrbpq_1
X_4424__502 VDD VSS _4424_/RESET_B sg13g2_tiehi
XFILLER_98_4 VDD VSS sg13g2_decap_4
XFILLER_91_70 VDD VSS sg13g2_fill_1
XFILLER_30_574 VDD VSS sg13g2_decap_8
X_4641_ fanout268/X VSS VDD _4641_/D _4641_/Q _4745_/CLK sg13g2_dfrbpq_1
X_4572_ fanout333/X VSS VDD _4572_/D _4572_/Q _4580_/CLK sg13g2_dfrbpq_1
Xhold737 _3480_/Y VDD VSS _4677_/D sg13g2_dlygate4sd3_1
Xhold726 _3267_/Y VDD VSS _4612_/D sg13g2_dlygate4sd3_1
Xhold715 _3589_/Y VDD VSS _4722_/D sg13g2_dlygate4sd3_1
Xhold704 _4823_/Q VDD VSS _2480_/B sg13g2_dlygate4sd3_1
X_3523_ _3523_/Y _3523_/A _3572_/A VDD VSS sg13g2_nand2_1
XFILLER_6_291 VDD VSS sg13g2_decap_8
Xhold759 _4080_/Y VDD VSS _4961_/D sg13g2_dlygate4sd3_1
Xhold748 _4677_/Q VDD VSS _3477_/A sg13g2_dlygate4sd3_1
X_3454_ _3453_/Y VDD _3454_/Y VSS _2271_/Y _3453_/C sg13g2_o21ai_1
XFILLER_89_508 VDD VSS sg13g2_decap_8
XFILLER_115_178 VDD VSS sg13g2_decap_8
XFILLER_41_0 VDD VSS sg13g2_decap_8
X_2405_ _2414_/B _2414_/C _2405_/A _2428_/B VDD VSS sg13g2_nand3_1
X_3385_ _3385_/A _3415_/B _3399_/C _3385_/D _3385_/Y VDD VSS sg13g2_nor4_1
XFILLER_69_287 VDD VSS sg13g2_fill_2
Xhold1404 _4760_/Q VDD VSS _3740_/A sg13g2_dlygate4sd3_1
Xhold1415 _4923_/Q VDD VSS _2814_/A sg13g2_dlygate4sd3_1
X_2336_ VDD _2742_/A _2336_/A VSS sg13g2_inv_1
XFILLER_97_574 VDD VSS sg13g2_decap_8
XFILLER_85_703 VDD VSS sg13g2_fill_1
XFILLER_111_395 VDD VSS sg13g2_decap_8
XFILLER_57_438 VDD VSS sg13g2_decap_8
XFILLER_84_213 VDD VSS sg13g2_decap_8
Xhold1426 _3593_/Y VDD VSS _4723_/D sg13g2_dlygate4sd3_1
Xhold1437 _4728_/Q VDD VSS _3612_/A sg13g2_dlygate4sd3_1
Xhold1448 _4563_/Q VDD VSS _3152_/A sg13g2_dlygate4sd3_1
Xhold1459 _4739_/Q VDD VSS hold1459/X sg13g2_dlygate4sd3_1
Xclkbuf_leaf_49_clk clkbuf_4_10_0_clk/X _4977_/CLK VDD VSS sg13g2_buf_8
X_2267_ VDD _2267_/Y _4662_/Q VSS sg13g2_inv_1
XFILLER_85_769 VDD VSS sg13g2_fill_2
X_4006_ _4006_/A _4006_/B _4842_/Q _4006_/Y VDD VSS sg13g2_nor3_1
XFILLER_52_110 VDD VSS sg13g2_decap_4
XFILLER_53_633 VDD VSS sg13g2_decap_8
XFILLER_65_493 VDD VSS sg13g2_decap_8
XFILLER_81_920 VDD VSS sg13g2_decap_4
XFILLER_111_14 VDD VSS sg13g2_decap_8
XFILLER_41_806 VDD VSS sg13g2_fill_2
XFILLER_80_430 VDD VSS sg13g2_decap_8
XFILLER_71_18 VDD VSS sg13g2_fill_1
X_4908_ fanout257/X VSS VDD _4908_/D _4908_/Q clkload7/A sg13g2_dfrbpq_1
XFILLER_21_563 VDD VSS sg13g2_decap_8
X_4839_ fanout275/X VSS VDD _4839_/D _4839_/Q _4954_/CLK sg13g2_dfrbpq_1
XFILLER_107_613 VDD VSS sg13g2_decap_8
XFILLER_5_718 VDD VSS sg13g2_decap_8
XFILLER_106_189 VDD VSS sg13g2_decap_8
XFILLER_0_445 VDD VSS sg13g2_decap_8
XFILLER_49_906 VDD VSS sg13g2_decap_8
XFILLER_88_530 VDD VSS sg13g2_decap_8
XFILLER_103_874 VDD VSS sg13g2_fill_1
XFILLER_29_53 VDD VSS sg13g2_decap_8
XFILLER_48_427 VDD VSS sg13g2_decap_8
XFILLER_76_725 VDD VSS sg13g2_fill_2
XFILLER_102_384 VDD VSS sg13g2_decap_8
XFILLER_29_652 VDD VSS sg13g2_decap_8
XFILLER_75_257 VDD VSS sg13g2_fill_1
XFILLER_75_279 VDD VSS sg13g2_decap_8
XFILLER_56_482 VDD VSS sg13g2_decap_8
XFILLER_84_780 VDD VSS sg13g2_fill_2
XFILLER_16_346 VDD VSS sg13g2_decap_8
XFILLER_17_869 VDD VSS sg13g2_fill_1
XFILLER_44_666 VDD VSS sg13g2_decap_8
XFILLER_45_74 VDD VSS sg13g2_decap_4
XFILLER_61_84 VDD VSS sg13g2_decap_8
XFILLER_6_57 VDD VSS sg13g2_decap_8
XFILLER_99_817 VDD VSS sg13g2_decap_4
XFILLER_113_616 VDD VSS sg13g2_fill_2
XFILLER_113_627 VDD VSS sg13g2_fill_2
XFILLER_113_638 VDD VSS sg13g2_decap_8
XFILLER_4_795 VDD VSS sg13g2_decap_8
XFILLER_99_839 VDD VSS sg13g2_decap_8
XFILLER_79_541 VDD VSS sg13g2_decap_8
XFILLER_67_725 VDD VSS sg13g2_decap_4
X_3170_ _3182_/A _3170_/B _4571_/D VDD VSS sg13g2_nor2_1
XFILLER_19_151 VDD VSS sg13g2_decap_8
XFILLER_35_622 VDD VSS sg13g2_decap_8
XFILLER_47_460 VDD VSS sg13g2_decap_8
XFILLER_34_132 VDD VSS sg13g2_fill_1
XFILLER_62_430 VDD VSS sg13g2_decap_8
XFILLER_34_154 VDD VSS sg13g2_decap_8
XFILLER_35_699 VDD VSS sg13g2_decap_4
XFILLER_50_625 VDD VSS sg13g2_decap_8
XFILLER_22_349 VDD VSS sg13g2_decap_8
X_4309__417 VDD VSS _4309_/RESET_B sg13g2_tiehi
X_2954_ hold985/X _3109_/A0 _2954_/S _2954_/X VDD VSS sg13g2_mux2_1
XFILLER_89_0 VDD VSS sg13g2_decap_8
X_2885_ _2885_/A0 _3017_/A1 _2900_/S _4318_/D VDD VSS sg13g2_mux2_1
X_4624_ fanout332/X VSS VDD _4624_/D _4624_/Q _4933_/CLK sg13g2_dfrbpq_1
X_4555_ fanout298/X VSS VDD _4555_/D _4555_/Q _4959_/CLK sg13g2_dfrbpq_1
XFILLER_116_443 VDD VSS sg13g2_decap_8
Xhold545 _3293_/Y VDD VSS _4623_/D sg13g2_dlygate4sd3_1
X_3506_ _3506_/A _3511_/B _3507_/B VDD VSS sg13g2_nor2_1
XFILLER_116_498 VDD VSS sg13g2_decap_8
Xhold556 _4838_/Q VDD VSS _4003_/A sg13g2_dlygate4sd3_1
Xhold567 _4882_/Q VDD VSS _2556_/B sg13g2_dlygate4sd3_1
Xhold578 _4878_/Q VDD VSS _2549_/A sg13g2_dlygate4sd3_1
X_4486_ fanout298/X VSS VDD _4486_/D _4486_/Q _4959_/CLK sg13g2_dfrbpq_1
XFILLER_89_338 VDD VSS sg13g2_decap_8
XFILLER_103_126 VDD VSS sg13g2_decap_8
Xhold589 _3131_/Y VDD VSS _4553_/D sg13g2_dlygate4sd3_1
X_3437_ _3453_/B _3447_/C _3437_/A _3437_/Y VDD VSS sg13g2_nand3_1
X_3368_ _3467_/A _3652_/A1 _3368_/S _4644_/D VDD VSS sg13g2_mux2_1
XFILLER_97_371 VDD VSS sg13g2_decap_8
XFILLER_100_833 VDD VSS sg13g2_decap_8
XFILLER_111_170 VDD VSS sg13g2_decap_8
XFILLER_112_682 VDD VSS sg13g2_decap_4
XFILLER_57_235 VDD VSS sg13g2_decap_8
XFILLER_58_736 VDD VSS sg13g2_decap_4
Xhold1201 _4457_/Q VDD VSS _3031_/A0 sg13g2_dlygate4sd3_1
Xhold1212 _4410_/Q VDD VSS _2981_/A0 sg13g2_dlygate4sd3_1
Xhold1223 _4308_/Q VDD VSS _2873_/A0 sg13g2_dlygate4sd3_1
Xhold1234 _4307_/Q VDD VSS _2872_/A0 sg13g2_dlygate4sd3_1
X_2319_ VDD _3390_/A _2319_/A VSS sg13g2_inv_1
XFILLER_85_533 VDD VSS sg13g2_decap_8
Xhold1245 _3174_/Y VDD VSS _3175_/B sg13g2_dlygate4sd3_1
Xhold1256 _3486_/Y VDD VSS _4680_/D sg13g2_dlygate4sd3_1
Xhold1267 _2838_/X VDD VSS _4275_/D sg13g2_dlygate4sd3_1
X_3299_ _3431_/A _3299_/A1 _3369_/S _4628_/D VDD VSS sg13g2_mux2_1
XFILLER_85_577 VDD VSS sg13g2_fill_1
XFILLER_26_600 VDD VSS sg13g2_fill_2
Xhold1278 _4332_/Q VDD VSS _2899_/A0 sg13g2_dlygate4sd3_1
Xhold1289 _4846_/Q VDD VSS _2638_/A1 sg13g2_dlygate4sd3_1
XFILLER_53_430 VDD VSS sg13g2_decap_8
XFILLER_72_249 VDD VSS sg13g2_decap_8
XFILLER_14_828 VDD VSS sg13g2_fill_1
XFILLER_15_11 VDD VSS sg13g2_fill_2
XFILLER_81_761 VDD VSS sg13g2_decap_8
XFILLER_13_327 VDD VSS sg13g2_decap_8
XFILLER_15_44 VDD VSS sg13g2_decap_4
XFILLER_15_66 VDD VSS sg13g2_decap_8
XFILLER_41_669 VDD VSS sg13g2_decap_8
XFILLER_31_21 VDD VSS sg13g2_decap_8
XFILLER_31_65 VDD VSS sg13g2_decap_8
XFILLER_31_76 VDD VSS sg13g2_fill_2
XFILLER_31_98 VDD VSS sg13g2_decap_8
XFILLER_5_559 VDD VSS sg13g2_decap_4
Xoutput10 _4933_/Q ir_tx_npn_drive VDD VSS sg13g2_buf_1
Xoutput21 _2234_/Y uart_tx VDD VSS sg13g2_buf_1
Xoutput8 _5180_/A busy VDD VSS sg13g2_buf_1
XFILLER_1_754 VDD VSS sg13g2_decap_8
XFILLER_0_231 VDD VSS sg13g2_decap_8
X_4414__512 VDD VSS _4414_/RESET_B sg13g2_tiehi
XFILLER_102_192 VDD VSS sg13g2_decap_8
XFILLER_36_419 VDD VSS sg13g2_decap_8
XFILLER_48_279 VDD VSS sg13g2_decap_8
XFILLER_56_84 VDD VSS sg13g2_decap_8
XFILLER_63_227 VDD VSS sg13g2_fill_1
XFILLER_64_728 VDD VSS sg13g2_fill_2
XFILLER_44_441 VDD VSS sg13g2_decap_8
XFILLER_17_699 VDD VSS sg13g2_fill_2
XFILLER_71_260 VDD VSS sg13g2_decap_8
XFILLER_72_794 VDD VSS sg13g2_decap_8
XFILLER_31_135 VDD VSS sg13g2_decap_8
XFILLER_82_7 VDD VSS sg13g2_decap_4
X_4421__505 VDD VSS _4421_/RESET_B sg13g2_tiehi
X_2670_ _2670_/B _2670_/C _4685_/Q _2670_/Y VDD VSS sg13g2_nand3_1
XFILLER_8_364 VDD VSS sg13g2_decap_8
XFILLER_9_898 VDD VSS sg13g2_decap_8
X_4340_ _4340_/RESET_B VSS VDD _4340_/D _4340_/Q _4964_/CLK sg13g2_dfrbpq_1
XFILLER_99_614 VDD VSS sg13g2_decap_8
X_4271_ _4271_/RESET_B VSS VDD _4271_/D _4271_/Q _4973_/CLK sg13g2_dfrbpq_1
XFILLER_101_619 VDD VSS sg13g2_fill_2
X_3222_ _3222_/Y _3222_/A _3222_/B VDD VSS sg13g2_xnor2_1
XFILLER_97_80 VDD VSS sg13g2_decap_8
XFILLER_67_511 VDD VSS sg13g2_fill_1
X_3153_ _3145_/B VDD _3153_/Y VSS _3144_/A _3153_/A2 sg13g2_o21ai_1
XFILLER_95_831 VDD VSS sg13g2_decap_8
XFILLER_48_780 VDD VSS sg13g2_decap_8
XFILLER_54_205 VDD VSS sg13g2_decap_8
X_3084_ _4246_/B _3084_/A1 _3084_/S _4508_/D VDD VSS sg13g2_mux2_1
XFILLER_63_750 VDD VSS sg13g2_decap_8
XFILLER_70_709 VDD VSS sg13g2_decap_8
XFILLER_82_558 VDD VSS sg13g2_fill_2
XFILLER_23_614 VDD VSS sg13g2_decap_4
XFILLER_35_452 VDD VSS sg13g2_decap_8
XFILLER_22_102 VDD VSS sg13g2_decap_8
XFILLER_50_433 VDD VSS sg13g2_fill_2
XFILLER_62_282 VDD VSS sg13g2_decap_8
XFILLER_90_591 VDD VSS sg13g2_decap_8
XFILLER_10_308 VDD VSS sg13g2_decap_4
XFILLER_22_135 VDD VSS sg13g2_decap_8
X_3986_ _3985_/Y VDD _3986_/Y VSS _3985_/B _3984_/Y sg13g2_o21ai_1
XFILLER_10_319 VDD VSS sg13g2_fill_1
X_2937_ _2937_/A0 _3092_/A0 _2955_/S _4367_/D VDD VSS sg13g2_mux2_1
XFILLER_31_691 VDD VSS sg13g2_decap_8
X_4607_ fanout277/X VSS VDD _4607_/D _4607_/Q _4950_/CLK sg13g2_dfrbpq_1
X_2868_ _2868_/A0 _3103_/A0 _2869_/S _2868_/X VDD VSS sg13g2_mux2_1
X_2799_ _2807_/A _2800_/B _2799_/C _2799_/Y VDD VSS sg13g2_nor3_1
X_4538_ fanout265/X VSS VDD _4538_/D _4538_/Q _4658_/CLK sg13g2_dfrbpq_1
XFILLER_104_435 VDD VSS sg13g2_decap_8
XFILLER_116_284 VDD VSS sg13g2_decap_8
XFILLER_78_809 VDD VSS sg13g2_decap_4
X_4469_ fanout321/X VSS VDD _4469_/D _4469_/Q _4979_/CLK sg13g2_dfrbpq_1
XFILLER_104_457 VDD VSS sg13g2_decap_8
XFILLER_112_490 VDD VSS sg13g2_decap_4
XFILLER_58_544 VDD VSS sg13g2_decap_8
Xhold1020 _3063_/X VDD VSS _4489_/D sg13g2_dlygate4sd3_1
Xhold1031 _2935_/X VDD VSS _4365_/D sg13g2_dlygate4sd3_1
Xhold1042 _4377_/Q VDD VSS _4175_/A0 sg13g2_dlygate4sd3_1
Xhold1053 _4426_/Q VDD VSS _2999_/A0 sg13g2_dlygate4sd3_1
Xhold1064 _3547_/X VDD VSS _4709_/D sg13g2_dlygate4sd3_1
Xhold1075 _2992_/X VDD VSS _4419_/D sg13g2_dlygate4sd3_1
Xhold1086 _4286_/Q VDD VSS _2851_/A0 sg13g2_dlygate4sd3_1
Xhold1097 _4343_/Q VDD VSS _2911_/A0 sg13g2_dlygate4sd3_1
XFILLER_26_43 VDD VSS sg13g2_decap_8
XFILLER_14_647 VDD VSS sg13g2_decap_8
XFILLER_26_496 VDD VSS sg13g2_fill_1
XFILLER_41_433 VDD VSS sg13g2_decap_8
XFILLER_41_466 VDD VSS sg13g2_decap_8
XFILLER_9_128 VDD VSS sg13g2_fill_1
XFILLER_9_117 VDD VSS sg13g2_decap_8
XFILLER_10_853 VDD VSS sg13g2_decap_8
XFILLER_42_86 VDD VSS sg13g2_decap_8
XFILLER_108_752 VDD VSS sg13g2_decap_8
XFILLER_5_356 VDD VSS sg13g2_decap_8
XFILLER_6_868 VDD VSS sg13g2_decap_8
XFILLER_110_405 VDD VSS sg13g2_decap_8
XFILLER_3_14 VDD VSS sg13g2_decap_8
XFILLER_49_500 VDD VSS sg13g2_decap_8
XFILLER_68_308 VDD VSS sg13g2_decap_8
XFILLER_68_319 VDD VSS sg13g2_fill_2
XFILLER_96_628 VDD VSS sg13g2_decap_8
XFILLER_89_680 VDD VSS sg13g2_decap_8
XFILLER_103_490 VDD VSS sg13g2_decap_8
XFILLER_49_577 VDD VSS sg13g2_decap_8
XFILLER_76_363 VDD VSS sg13g2_fill_1
XFILLER_92_823 VDD VSS sg13g2_decap_8
XFILLER_91_300 VDD VSS sg13g2_decap_8
XFILLER_64_569 VDD VSS sg13g2_decap_8
XFILLER_33_923 VDD VSS sg13g2_fill_2
XFILLER_51_219 VDD VSS sg13g2_decap_8
XFILLER_83_60 VDD VSS sg13g2_decap_8
XFILLER_32_411 VDD VSS sg13g2_fill_2
XFILLER_32_455 VDD VSS sg13g2_decap_8
X_3840_ _3840_/Y _3852_/A _3839_/Y _3791_/S _3325_/A VDD VSS sg13g2_a22oi_1
XFILLER_60_797 VDD VSS sg13g2_decap_8
X_3771_ VSS VDD _3768_/A _3770_/C _3772_/C _3841_/A sg13g2_a21oi_1
X_2722_ VSS VDD _2752_/A _2749_/A _2722_/A sg13g2_or2_1
X_2653_ _3514_/B _2654_/A _3511_/B VDD VSS sg13g2_nand2_1
X_2584_ _2584_/Y _2584_/A _2584_/B VDD VSS sg13g2_xnor2_1
X_4323_ _4323_/RESET_B VSS VDD _4323_/D _4323_/Q _4967_/CLK sg13g2_dfrbpq_1
XFILLER_114_766 VDD VSS sg13g2_fill_2
Xfanout107 fanout108/X _2869_/S VDD VSS sg13g2_buf_1
Xfanout118 _3553_/S _3551_/S VDD VSS sg13g2_buf_1
Xfanout129 _3082_/S _3085_/S VDD VSS sg13g2_buf_1
XFILLER_99_488 VDD VSS sg13g2_decap_8
XFILLER_101_427 VDD VSS sg13g2_decap_8
X_4254_ _4169_/A VDD _4254_/Y VSS _4254_/A1 _4248_/X sg13g2_o21ai_1
XFILLER_86_116 VDD VSS sg13g2_decap_8
XFILLER_67_352 VDD VSS sg13g2_fill_2
X_4185_ _4184_/Y VDD _4191_/B VSS _4181_/Y _4182_/Y sg13g2_o21ai_1
X_3205_ _2645_/A VDD _4586_/D VSS _3193_/B _3205_/A2 sg13g2_o21ai_1
XFILLER_95_650 VDD VSS sg13g2_decap_8
XFILLER_55_525 VDD VSS sg13g2_decap_4
XFILLER_82_311 VDD VSS sg13g2_decap_8
X_3136_ _3136_/Y _3136_/A _3136_/B VDD VSS sg13g2_nand2_1
XFILLER_82_344 VDD VSS sg13g2_decap_4
X_3067_ _3067_/Y _3067_/A _3085_/S VDD VSS sg13g2_nand2_1
XFILLER_103_59 VDD VSS sg13g2_decap_8
XFILLER_70_506 VDD VSS sg13g2_decap_8
XFILLER_23_422 VDD VSS sg13g2_fill_2
XFILLER_51_731 VDD VSS sg13g2_decap_8
XFILLER_63_580 VDD VSS sg13g2_decap_8
XFILLER_50_263 VDD VSS sg13g2_decap_8
XFILLER_51_786 VDD VSS sg13g2_decap_8
X_3969_ VSS VDD _3977_/S _3972_/D _3969_/Y _2634_/B sg13g2_a21oi_1
X_4404__522 VDD VSS _4404_/RESET_B sg13g2_tiehi
XFILLER_12_67 VDD VSS sg13g2_decap_8
XFILLER_3_849 VDD VSS sg13g2_decap_8
XFILLER_105_766 VDD VSS sg13g2_decap_4
XFILLER_78_617 VDD VSS sg13g2_fill_2
XFILLER_104_276 VDD VSS sg13g2_fill_1
XFILLER_77_138 VDD VSS sg13g2_decap_8
XFILLER_78_639 VDD VSS sg13g2_decap_8
XFILLER_93_609 VDD VSS sg13g2_fill_2
XFILLER_19_739 VDD VSS sg13g2_decap_8
XFILLER_37_42 VDD VSS sg13g2_decap_8
XFILLER_100_482 VDD VSS sg13g2_decap_8
XFILLER_18_238 VDD VSS sg13g2_decap_8
XFILLER_85_182 VDD VSS sg13g2_decap_8
X_4411__515 VDD VSS _4411_/RESET_B sg13g2_tiehi
XFILLER_15_901 VDD VSS sg13g2_decap_8
XFILLER_74_878 VDD VSS sg13g2_fill_2
XFILLER_14_411 VDD VSS sg13g2_decap_8
XFILLER_26_282 VDD VSS sg13g2_decap_8
XFILLER_33_219 VDD VSS sg13g2_decap_4
XFILLER_42_720 VDD VSS sg13g2_decap_8
XFILLER_54_580 VDD VSS sg13g2_decap_4
XFILLER_73_388 VDD VSS sg13g2_fill_2
XFILLER_41_263 VDD VSS sg13g2_decap_8
XFILLER_41_274 VDD VSS sg13g2_fill_2
XFILLER_42_797 VDD VSS sg13g2_decap_8
XFILLER_10_672 VDD VSS sg13g2_decap_8
XFILLER_108_560 VDD VSS sg13g2_decap_8
XFILLER_6_676 VDD VSS sg13g2_decap_4
XFILLER_45_7 VDD VSS sg13g2_decap_8
XFILLER_110_213 VDD VSS sg13g2_decap_8
XFILLER_68_116 VDD VSS sg13g2_decap_8
XFILLER_96_458 VDD VSS sg13g2_decap_4
XFILLER_65_823 VDD VSS sg13g2_decap_8
XFILLER_49_385 VDD VSS sg13g2_fill_1
XFILLER_49_396 VDD VSS sg13g2_decap_8
XFILLER_64_333 VDD VSS sg13g2_decap_8
XFILLER_64_344 VDD VSS sg13g2_fill_2
XFILLER_76_171 VDD VSS sg13g2_decap_8
XFILLER_77_694 VDD VSS sg13g2_decap_8
XFILLER_92_620 VDD VSS sg13g2_decap_8
XFILLER_25_709 VDD VSS sg13g2_decap_8
XFILLER_37_569 VDD VSS sg13g2_decap_8
XFILLER_91_130 VDD VSS sg13g2_decap_4
XFILLER_80_848 VDD VSS sg13g2_decap_8
X_4941_ fanout334/X VSS VDD _4941_/D _4941_/Q _4941_/CLK sg13g2_dfrbpq_1
XFILLER_92_697 VDD VSS sg13g2_fill_2
XFILLER_91_185 VDD VSS sg13g2_decap_8
X_4872_ fanout304/X VSS VDD _4872_/D _4872_/Q _4877_/CLK sg13g2_dfrbpq_1
XFILLER_32_252 VDD VSS sg13g2_decap_4
XFILLER_33_797 VDD VSS sg13g2_fill_1
X_3823_ VSS VDD _3820_/A _3820_/B _3823_/Y _2295_/Y sg13g2_a21oi_1
XFILLER_71_0 VDD VSS sg13g2_decap_8
X_3754_ _3754_/B1 VDD _3754_/Y VSS _3826_/A _2757_/Y sg13g2_o21ai_1
X_3685_ _4731_/Q VDD _3687_/B VSS _4730_/Q _3686_/C sg13g2_o21ai_1
X_2705_ _2705_/A _4859_/Q _2705_/Y VDD VSS sg13g2_nor2_1
X_2636_ _2637_/A _2634_/Y _3977_/S _3972_/D _2721_/B VDD VSS sg13g2_a22oi_1
XFILLER_114_563 VDD VSS sg13g2_fill_1
X_2567_ _2572_/A _2572_/B _2569_/B VDD VSS sg13g2_nor2_1
XFILLER_88_915 VDD VSS sg13g2_decap_8
XFILLER_102_714 VDD VSS sg13g2_decap_8
X_4306_ _4306_/RESET_B VSS VDD _4306_/D _4306_/Q _4976_/CLK sg13g2_dfrbpq_1
X_2498_ _3555_/A _2498_/B _2499_/B VDD VSS sg13g2_and2_1
XFILLER_114_25 VDD VSS sg13g2_fill_2
X_4237_ _4237_/Y _4237_/B _4236_/B1 VDD VSS sg13g2_nand2b_1
XFILLER_114_36 VDD VSS sg13g2_decap_8
XFILLER_28_503 VDD VSS sg13g2_decap_4
XFILLER_56_823 VDD VSS sg13g2_decap_8
XFILLER_110_791 VDD VSS sg13g2_decap_8
XFILLER_83_642 VDD VSS sg13g2_decap_8
X_4168_ VSS VDD _4250_/B1 _4164_/X _4168_/Y _4167_/Y sg13g2_a21oi_1
XFILLER_95_480 VDD VSS sg13g2_decap_8
XFILLER_15_208 VDD VSS sg13g2_decap_8
XFILLER_16_709 VDD VSS sg13g2_fill_1
XFILLER_55_344 VDD VSS sg13g2_decap_8
XFILLER_71_804 VDD VSS sg13g2_fill_2
XFILLER_83_686 VDD VSS sg13g2_fill_1
X_4099_ _4098_/Y VDD _4100_/C VSS _4095_/Y _4096_/Y sg13g2_o21ai_1
X_3119_ _4646_/Q _3119_/A1 _3128_/B _3119_/X VDD VSS sg13g2_mux2_1
XFILLER_15_219 VDD VSS sg13g2_fill_2
XFILLER_70_325 VDD VSS sg13g2_decap_8
XFILLER_71_837 VDD VSS sg13g2_decap_8
XFILLER_11_403 VDD VSS sg13g2_decap_8
XFILLER_23_274 VDD VSS sg13g2_decap_8
XFILLER_109_324 VDD VSS sg13g2_decap_8
XFILLER_3_602 VDD VSS sg13g2_decap_8
XFILLER_2_101 VDD VSS sg13g2_fill_2
XFILLER_2_134 VDD VSS sg13g2_fill_2
XFILLER_105_574 VDD VSS sg13g2_decap_8
XFILLER_105_585 VDD VSS sg13g2_fill_1
XFILLER_48_52 VDD VSS sg13g2_decap_8
XFILLER_78_447 VDD VSS sg13g2_decap_8
XFILLER_46_333 VDD VSS sg13g2_decap_4
XFILLER_86_480 VDD VSS sg13g2_decap_8
XFILLER_73_152 VDD VSS sg13g2_fill_1
XFILLER_74_653 VDD VSS sg13g2_decap_8
XFILLER_46_388 VDD VSS sg13g2_decap_8
XFILLER_61_336 VDD VSS sg13g2_decap_8
XFILLER_62_837 VDD VSS sg13g2_decap_8
XFILLER_14_241 VDD VSS sg13g2_decap_4
XFILLER_30_723 VDD VSS sg13g2_decap_8
XFILLER_70_892 VDD VSS sg13g2_decap_8
XFILLER_14_285 VDD VSS sg13g2_decap_8
XFILLER_42_594 VDD VSS sg13g2_decap_8
XFILLER_116_817 VDD VSS sg13g2_decap_8
Xhold919 _4383_/Q VDD VSS hold919/X sg13g2_dlygate4sd3_1
Xhold908 _4502_/Q VDD VSS hold908/X sg13g2_dlygate4sd3_1
X_3470_ _3469_/Y VDD _4672_/D VSS _2288_/Y _3469_/C sg13g2_o21ai_1
X_2421_ _2818_/B _2358_/A _2807_/A _2421_/X VDD VSS sg13g2_a21o_1
XFILLER_69_425 VDD VSS sg13g2_decap_8
X_2352_ VDD _2352_/Y _2352_/A VSS sg13g2_inv_1
Xhold1608 _3757_/Y VDD VSS _4765_/D sg13g2_dlygate4sd3_1
X_2283_ VDD _2283_/Y _3479_/A VSS sg13g2_inv_1
XFILLER_96_255 VDD VSS sg13g2_decap_8
XFILLER_56_119 VDD VSS sg13g2_decap_8
XFILLER_84_406 VDD VSS sg13g2_decap_8
Xhold1619 _3819_/Y VDD VSS _4780_/D sg13g2_dlygate4sd3_1
X_4022_ _4218_/A1 VDD _4022_/Y VSS _4020_/Y _4021_/Y sg13g2_o21ai_1
XFILLER_38_834 VDD VSS sg13g2_fill_2
XFILLER_38_856 VDD VSS sg13g2_decap_8
XFILLER_49_171 VDD VSS sg13g2_decap_8
XFILLER_65_675 VDD VSS sg13g2_decap_8
XFILLER_25_528 VDD VSS sg13g2_decap_8
XFILLER_37_399 VDD VSS sg13g2_decap_8
XFILLER_92_494 VDD VSS sg13g2_decap_8
X_4924_ fanout260/X VSS VDD _4924_/D _4924_/Q clkload5/A sg13g2_dfrbpq_1
XFILLER_21_712 VDD VSS sg13g2_decap_4
XFILLER_21_734 VDD VSS sg13g2_decap_8
X_4855_ fanout315/X VSS VDD _4855_/D _4855_/Q _4929_/CLK sg13g2_dfrbpq_1
X_4786_ fanout250/X VSS VDD _4786_/D _4786_/Q clkload0/A sg13g2_dfrbpq_1
X_3806_ _3806_/Y _3848_/A _4757_/Q VDD VSS sg13g2_nand2b_1
XFILLER_109_14 VDD VSS sg13g2_decap_8
X_3737_ _3737_/Y _3740_/B _3737_/B VDD VSS sg13g2_nand2_1
XFILLER_107_839 VDD VSS sg13g2_decap_8
X_4401__525 VDD VSS _4401_/RESET_B sg13g2_tiehi
X_3668_ _3694_/A _3717_/A _3668_/Y VDD VSS sg13g2_nor2b_1
X_3599_ _3599_/Y _3599_/A _3599_/B VDD VSS sg13g2_xnor2_1
X_2619_ _2619_/B _3286_/B _3242_/B VDD VSS hold729/X sg13g2_nand3b_1
XFILLER_0_627 VDD VSS sg13g2_decap_8
XFILLER_102_500 VDD VSS sg13g2_decap_8
XFILLER_114_393 VDD VSS sg13g2_fill_2
XFILLER_88_778 VDD VSS sg13g2_fill_1
XFILLER_88_767 VDD VSS sg13g2_decap_8
XFILLER_29_812 VDD VSS sg13g2_decap_8
XFILLER_87_277 VDD VSS sg13g2_decap_8
XFILLER_28_300 VDD VSS sg13g2_decap_8
XFILLER_18_77 VDD VSS sg13g2_decap_8
XFILLER_28_344 VDD VSS sg13g2_decap_8
XFILLER_44_804 VDD VSS sg13g2_decap_8
XFILLER_55_130 VDD VSS sg13g2_decap_4
XFILLER_16_517 VDD VSS sg13g2_decap_8
XFILLER_18_99 VDD VSS sg13g2_fill_2
XFILLER_55_185 VDD VSS sg13g2_decap_8
XFILLER_52_870 VDD VSS sg13g2_fill_2
XFILLER_70_177 VDD VSS sg13g2_decap_8
XFILLER_71_678 VDD VSS sg13g2_decap_8
XFILLER_12_723 VDD VSS sg13g2_decap_8
XFILLER_34_76 VDD VSS sg13g2_fill_2
XFILLER_51_380 VDD VSS sg13g2_fill_1
XFILLER_12_789 VDD VSS sg13g2_decap_4
XFILLER_50_42 VDD VSS sg13g2_decap_8
XFILLER_7_237 VDD VSS sg13g2_decap_8
XFILLER_4_900 VDD VSS sg13g2_decap_8
XFILLER_50_75 VDD VSS sg13g2_decap_8
XFILLER_109_187 VDD VSS sg13g2_decap_4
XFILLER_3_454 VDD VSS sg13g2_fill_1
XFILLER_112_308 VDD VSS sg13g2_decap_8
XFILLER_1_0 VDD VSS sg13g2_decap_8
XFILLER_79_723 VDD VSS sg13g2_fill_2
XFILLER_78_222 VDD VSS sg13g2_decap_8
XFILLER_79_756 VDD VSS sg13g2_fill_1
XFILLER_94_737 VDD VSS sg13g2_decap_8
XFILLER_47_620 VDD VSS sg13g2_decap_4
XFILLER_59_491 VDD VSS sg13g2_decap_8
Xfanout290 fanout291/X fanout290/X VDD VSS sg13g2_buf_1
XFILLER_19_333 VDD VSS sg13g2_decap_8
XFILLER_75_72 VDD VSS sg13g2_decap_8
XFILLER_34_347 VDD VSS sg13g2_decap_8
XFILLER_34_358 VDD VSS sg13g2_fill_1
XFILLER_61_144 VDD VSS sg13g2_decap_8
XFILLER_15_550 VDD VSS sg13g2_decap_8
XFILLER_50_829 VDD VSS sg13g2_decap_8
X_2970_ _4144_/A1 _3023_/A1 _2979_/S _2970_/X VDD VSS sg13g2_mux2_1
XFILLER_15_594 VDD VSS sg13g2_decap_8
X_4640_ fanout272/X VSS VDD _4640_/D _4640_/Q _4749_/CLK sg13g2_dfrbpq_1
XFILLER_116_603 VDD VSS sg13g2_decap_8
X_4571_ fanout333/X VSS VDD _4571_/D _4571_/Q _4580_/CLK sg13g2_dfrbpq_1
XFILLER_6_270 VDD VSS sg13g2_decap_8
Xhold727 _4816_/Q VDD VSS _3935_/B sg13g2_dlygate4sd3_1
Xhold716 _4875_/Q VDD VSS _2543_/A sg13g2_dlygate4sd3_1
Xhold705 _3958_/Y VDD VSS _4823_/D sg13g2_dlygate4sd3_1
X_3522_ _3522_/A _3522_/B _3522_/C _3596_/B VDD VSS sg13g2_nor3_1
XFILLER_104_809 VDD VSS sg13g2_fill_1
XFILLER_115_157 VDD VSS sg13g2_decap_8
Xhold749 _3478_/Y VDD VSS _4676_/D sg13g2_dlygate4sd3_1
Xhold738 _4803_/Q VDD VSS _2474_/D sg13g2_dlygate4sd3_1
X_3453_ _3453_/B _3453_/C _3453_/A _3453_/Y VDD VSS sg13g2_nand3_1
XFILLER_103_319 VDD VSS sg13g2_decap_8
XFILLER_69_200 VDD VSS sg13g2_decap_8
X_2404_ _2401_/X _2358_/Y _2402_/Y _3407_/A VDD VSS sg13g2_a21o_1
XFILLER_34_0 VDD VSS sg13g2_decap_8
X_3384_ _4780_/Q _3412_/B _3385_/D VDD VSS sg13g2_nor2_1
XFILLER_97_553 VDD VSS sg13g2_decap_8
XFILLER_69_266 VDD VSS sg13g2_decap_8
XFILLER_84_203 VDD VSS sg13g2_fill_1
Xhold1405 _3741_/Y VDD VSS _4760_/D sg13g2_dlygate4sd3_1
Xhold1416 _2814_/Y VDD VSS _2816_/A sg13g2_dlygate4sd3_1
X_2335_ VDD _2461_/B _4947_/Q VSS sg13g2_inv_1
XFILLER_111_385 VDD VSS sg13g2_decap_4
XFILLER_29_119 VDD VSS sg13g2_decap_8
XFILLER_69_299 VDD VSS sg13g2_decap_8
Xhold1427 _4672_/Q VDD VSS _3467_/A sg13g2_dlygate4sd3_1
Xhold1438 _3613_/Y VDD VSS _4728_/D sg13g2_dlygate4sd3_1
Xhold1449 _3152_/Y VDD VSS _3153_/A2 sg13g2_dlygate4sd3_1
X_2266_ VDD _2266_/Y _3429_/A VSS sg13g2_inv_1
XFILLER_26_804 VDD VSS sg13g2_decap_8
X_4005_ _4004_/Y VDD _4005_/Y VSS _2722_/A _4004_/B sg13g2_o21ai_1
XFILLER_38_686 VDD VSS sg13g2_fill_2
XFILLER_25_347 VDD VSS sg13g2_decap_8
XFILLER_52_144 VDD VSS sg13g2_decap_8
XFILLER_52_199 VDD VSS sg13g2_decap_8
X_4907_ fanout257/X VSS VDD _4907_/D _4907_/Q _4907_/CLK sg13g2_dfrbpq_1
X_4838_ fanout269/X VSS VDD _4838_/D _4838_/Q _4841_/CLK sg13g2_dfrbpq_1
X_4325__401 VDD VSS _4325_/RESET_B sg13g2_tiehi
X_4769_ fanout246/X VSS VDD _4769_/D _4769_/Q clkload1/A sg13g2_dfrbpq_1
XFILLER_112_7 VDD VSS sg13g2_decap_8
XFILLER_106_135 VDD VSS sg13g2_decap_8
XFILLER_106_146 VDD VSS sg13g2_fill_2
XFILLER_106_168 VDD VSS sg13g2_decap_8
XFILLER_115_680 VDD VSS sg13g2_decap_8
XFILLER_0_424 VDD VSS sg13g2_decap_8
XFILLER_103_853 VDD VSS sg13g2_fill_2
XFILLER_115_691 VDD VSS sg13g2_fill_2
XFILLER_102_363 VDD VSS sg13g2_decap_8
XFILLER_29_32 VDD VSS sg13g2_decap_8
XFILLER_48_406 VDD VSS sg13g2_decap_8
XFILLER_102_396 VDD VSS sg13g2_decap_8
XFILLER_29_631 VDD VSS sg13g2_decap_8
XFILLER_76_737 VDD VSS sg13g2_decap_4
XFILLER_76_759 VDD VSS sg13g2_decap_8
XFILLER_63_409 VDD VSS sg13g2_decap_8
XFILLER_16_303 VDD VSS sg13g2_fill_1
XFILLER_28_163 VDD VSS sg13g2_fill_1
XFILLER_43_111 VDD VSS sg13g2_decap_8
XFILLER_44_645 VDD VSS sg13g2_decap_8
XFILLER_71_453 VDD VSS sg13g2_fill_1
XFILLER_71_486 VDD VSS sg13g2_decap_8
XFILLER_43_188 VDD VSS sg13g2_fill_2
XFILLER_12_542 VDD VSS sg13g2_decap_4
XFILLER_40_895 VDD VSS sg13g2_fill_1
XFILLER_61_63 VDD VSS sg13g2_decap_8
XFILLER_8_557 VDD VSS sg13g2_decap_4
XFILLER_6_36 VDD VSS sg13g2_decap_8
XFILLER_112_105 VDD VSS sg13g2_decap_8
XFILLER_4_774 VDD VSS sg13g2_decap_8
XFILLER_98_317 VDD VSS sg13g2_decap_8
XFILLER_79_520 VDD VSS sg13g2_decap_8
XFILLER_66_225 VDD VSS sg13g2_decap_8
XFILLER_79_597 VDD VSS sg13g2_decap_8
XFILLER_94_545 VDD VSS sg13g2_decap_8
XFILLER_94_556 VDD VSS sg13g2_fill_1
XFILLER_81_206 VDD VSS sg13g2_fill_1
XFILLER_35_678 VDD VSS sg13g2_decap_8
XFILLER_16_881 VDD VSS sg13g2_decap_4
XFILLER_22_328 VDD VSS sg13g2_decap_8
XFILLER_50_659 VDD VSS sg13g2_decap_8
XFILLER_62_486 VDD VSS sg13g2_decap_8
X_2953_ hold919/X _3032_/A1 _2953_/S _2953_/X VDD VSS sg13g2_mux2_1
XFILLER_30_361 VDD VSS sg13g2_fill_1
X_2884_ _2884_/A0 _3092_/A0 _2902_/S _4317_/D VDD VSS sg13g2_mux2_1
X_4623_ fanout317/X VSS VDD _4623_/D _4623_/Q _4929_/CLK sg13g2_dfrbpq_1
XFILLER_116_422 VDD VSS sg13g2_decap_8
X_4554_ fanout296/X VSS VDD _4554_/D _4554_/Q _4960_/CLK sg13g2_dfrbpq_1
X_3505_ VSS VDD _3503_/A _3504_/Y _4684_/D _3503_/Y sg13g2_a21oi_1
XFILLER_103_105 VDD VSS sg13g2_fill_2
XFILLER_116_477 VDD VSS sg13g2_decap_8
Xhold546 _4897_/Q VDD VSS _4258_/A sg13g2_dlygate4sd3_1
Xhold557 _4934_/Q VDD VSS _2766_/B sg13g2_dlygate4sd3_1
Xhold568 _2557_/Y VDD VSS _2558_/B sg13g2_dlygate4sd3_1
Xhold579 _2549_/Y VDD VSS _4878_/D sg13g2_dlygate4sd3_1
X_4485_ fanout328/X VSS VDD _4485_/D _4485_/Q _4955_/CLK sg13g2_dfrbpq_1
X_3436_ _3435_/Y VDD _4655_/D VSS _2270_/Y _3471_/C sg13g2_o21ai_1
XFILLER_100_812 VDD VSS sg13g2_decap_8
XFILLER_58_715 VDD VSS sg13g2_decap_8
X_3367_ _3465_/A _3651_/A1 _3368_/S _4643_/D VDD VSS sg13g2_mux2_1
XFILLER_57_214 VDD VSS sg13g2_decap_8
Xhold1202 _4644_/Q VDD VSS _3652_/A1 sg13g2_dlygate4sd3_1
Xhold1213 _2981_/X VDD VSS _4410_/D sg13g2_dlygate4sd3_1
Xhold1224 _4694_/Q VDD VSS _3532_/A0 sg13g2_dlygate4sd3_1
X_2318_ VDD _3415_/A _2318_/A VSS sg13g2_inv_1
Xhold1235 _4579_/Q VDD VSS _2515_/B sg13g2_dlygate4sd3_1
Xhold1246 _4264_/Q VDD VSS _2827_/A0 sg13g2_dlygate4sd3_1
Xhold1257 _4548_/Q VDD VSS _3124_/A1 sg13g2_dlygate4sd3_1
X_3298_ _3429_/A hold954/X _3369_/S _4627_/D VDD VSS sg13g2_mux2_1
XFILLER_26_612 VDD VSS sg13g2_fill_1
XFILLER_54_910 VDD VSS sg13g2_decap_8
XFILLER_72_228 VDD VSS sg13g2_decap_8
Xhold1268 _4476_/Q VDD VSS _3537_/A1 sg13g2_dlygate4sd3_1
Xhold1279 _4337_/Q VDD VSS _2905_/A0 sg13g2_dlygate4sd3_1
X_2249_ VDD _2249_/Y _3935_/C VSS sg13g2_inv_1
XFILLER_26_667 VDD VSS sg13g2_fill_2
XFILLER_21_350 VDD VSS sg13g2_decap_4
XFILLER_5_505 VDD VSS sg13g2_decap_4
Xclkbuf_4_10_0_clk clkbuf_0_clk/X clkbuf_4_10_0_clk/X VDD VSS sg13g2_buf_8
Xoutput11 _3242_/B ld0 VDD VSS sg13g2_buf_1
Xoutput9 _3189_/B error VDD VSS sg13g2_buf_1
XFILLER_0_210 VDD VSS sg13g2_decap_8
XFILLER_107_499 VDD VSS sg13g2_decap_8
XFILLER_1_733 VDD VSS sg13g2_decap_8
XFILLER_89_873 VDD VSS sg13g2_decap_8
XFILLER_102_171 VDD VSS sg13g2_decap_8
XFILLER_103_683 VDD VSS sg13g2_decap_8
XFILLER_48_203 VDD VSS sg13g2_fill_1
XFILLER_88_383 VDD VSS sg13g2_decap_8
XFILLER_0_298 VDD VSS sg13g2_decap_8
XFILLER_48_258 VDD VSS sg13g2_decap_8
XFILLER_64_707 VDD VSS sg13g2_decap_8
XFILLER_76_567 VDD VSS sg13g2_decap_8
XFILLER_56_63 VDD VSS sg13g2_decap_8
XFILLER_91_504 VDD VSS sg13g2_decap_4
XFILLER_56_280 VDD VSS sg13g2_decap_8
XFILLER_16_144 VDD VSS sg13g2_decap_8
XFILLER_16_166 VDD VSS sg13g2_decap_4
XFILLER_72_751 VDD VSS sg13g2_decap_8
XFILLER_16_188 VDD VSS sg13g2_decap_8
XFILLER_16_199 VDD VSS sg13g2_fill_1
XFILLER_72_51 VDD VSS sg13g2_decap_8
XFILLER_72_95 VDD VSS sg13g2_fill_2
XFILLER_8_310 VDD VSS sg13g2_fill_1
XFILLER_75_7 VDD VSS sg13g2_fill_1
XFILLER_9_877 VDD VSS sg13g2_decap_8
XFILLER_8_343 VDD VSS sg13g2_decap_8
X_4270_ _4270_/RESET_B VSS VDD _4270_/D _4270_/Q _4737_/CLK sg13g2_dfrbpq_1
XFILLER_99_659 VDD VSS sg13g2_decap_4
X_3221_ _3230_/A _3221_/B _4593_/D VDD VSS sg13g2_nor2_1
XFILLER_39_225 VDD VSS sg13g2_decap_4
X_3152_ _3152_/Y _3152_/A _3152_/B VDD VSS sg13g2_xnor2_1
XFILLER_94_320 VDD VSS sg13g2_decap_8
X_4315__411 VDD VSS _4315_/RESET_B sg13g2_tiehi
XFILLER_36_921 VDD VSS sg13g2_decap_4
X_3083_ _4237_/B hold999/X _3083_/S _4507_/D VDD VSS sg13g2_mux2_1
XFILLER_54_239 VDD VSS sg13g2_decap_8
XFILLER_82_537 VDD VSS sg13g2_decap_8
XFILLER_82_548 VDD VSS sg13g2_fill_1
XFILLER_23_648 VDD VSS sg13g2_decap_4
XFILLER_50_412 VDD VSS sg13g2_decap_8
XFILLER_62_261 VDD VSS sg13g2_decap_8
XFILLER_90_570 VDD VSS sg13g2_decap_8
X_3985_ _3985_/Y _3985_/A _3985_/B VDD VSS sg13g2_nand2_1
X_2936_ _2936_/A0 _3091_/A0 _2954_/S _2936_/X VDD VSS sg13g2_mux2_1
X_2867_ hold847/X _3026_/A1 _2874_/S _2867_/X VDD VSS sg13g2_mux2_1
X_4606_ fanout277/X VSS VDD _4606_/D _4606_/Q _4950_/CLK sg13g2_dfrbpq_1
X_4322__404 VDD VSS _4322_/RESET_B sg13g2_tiehi
X_2798_ _2798_/A _2798_/B _2798_/Y VDD VSS sg13g2_nor2_1
XFILLER_104_414 VDD VSS sg13g2_decap_8
XFILLER_116_263 VDD VSS sg13g2_decap_8
X_4537_ fanout264/X VSS VDD _4537_/D _4537_/Q _4658_/CLK sg13g2_dfrbpq_1
X_4468_ fanout328/X VSS VDD _4468_/D _4468_/Q _4729_/CLK sg13g2_dfrbpq_1
XFILLER_77_309 VDD VSS sg13g2_decap_8
X_3419_ _4792_/Q _4793_/Q _3419_/C _3420_/D VDD VSS sg13g2_nor3_1
X_4399_ _4399_/RESET_B VSS VDD _4399_/D _4399_/Q _4968_/CLK sg13g2_dfrbpq_1
XFILLER_98_670 VDD VSS sg13g2_decap_4
XFILLER_86_810 VDD VSS sg13g2_decap_8
XFILLER_100_631 VDD VSS sg13g2_decap_8
XFILLER_85_353 VDD VSS sg13g2_decap_4
Xhold1010 _4312_/Q VDD VSS _2879_/A0 sg13g2_dlygate4sd3_1
Xhold1021 _4506_/Q VDD VSS _3082_/A1 sg13g2_dlygate4sd3_1
Xhold1032 _4379_/Q VDD VSS _2949_/A0 sg13g2_dlygate4sd3_1
XFILLER_86_876 VDD VSS sg13g2_decap_8
Xhold1043 _2947_/X VDD VSS _4377_/D sg13g2_dlygate4sd3_1
Xhold1054 _4388_/Q VDD VSS _4031_/A1 sg13g2_dlygate4sd3_1
Xhold1065 _4393_/Q VDD VSS _2964_/A0 sg13g2_dlygate4sd3_1
Xhold1076 _4831_/Q VDD VSS _3978_/A1 sg13g2_dlygate4sd3_1
XFILLER_86_887 VDD VSS sg13g2_fill_2
XFILLER_100_697 VDD VSS sg13g2_decap_8
XFILLER_26_22 VDD VSS sg13g2_decap_8
XFILLER_45_239 VDD VSS sg13g2_decap_8
Xhold1087 _4310_/Q VDD VSS _2875_/A0 sg13g2_dlygate4sd3_1
Xhold1098 _4328_/Q VDD VSS _2895_/A0 sg13g2_dlygate4sd3_1
XFILLER_26_464 VDD VSS sg13g2_decap_8
XFILLER_54_762 VDD VSS sg13g2_fill_2
XFILLER_14_615 VDD VSS sg13g2_fill_1
XFILLER_14_626 VDD VSS sg13g2_decap_8
XFILLER_42_924 VDD VSS sg13g2_fill_2
XFILLER_41_456 VDD VSS sg13g2_fill_1
XFILLER_10_832 VDD VSS sg13g2_decap_8
XFILLER_42_65 VDD VSS sg13g2_decap_8
XFILLER_5_302 VDD VSS sg13g2_decap_8
XFILLER_5_335 VDD VSS sg13g2_decap_8
XFILLER_6_847 VDD VSS sg13g2_decap_8
XFILLER_101_0 VDD VSS sg13g2_decap_8
XFILLER_1_552 VDD VSS sg13g2_decap_8
XFILLER_95_139 VDD VSS sg13g2_fill_2
XFILLER_49_534 VDD VSS sg13g2_fill_1
XFILLER_67_84 VDD VSS sg13g2_decap_8
XFILLER_64_548 VDD VSS sg13g2_decap_8
XFILLER_92_868 VDD VSS sg13g2_decap_8
XFILLER_92_857 VDD VSS sg13g2_fill_2
XFILLER_17_464 VDD VSS sg13g2_decap_8
XFILLER_44_250 VDD VSS sg13g2_fill_2
XFILLER_60_721 VDD VSS sg13g2_decap_4
XFILLER_91_389 VDD VSS sg13g2_decap_8
XFILLER_60_776 VDD VSS sg13g2_decap_8
X_3770_ _3779_/C _4769_/Q _4768_/Q _3770_/C VDD VSS sg13g2_and3_1
X_2721_ _4006_/B _2721_/B _2721_/C _2741_/A VDD VSS sg13g2_nor3_1
X_2652_ _2652_/A _3503_/A _3511_/B VDD VSS sg13g2_nor2_1
XFILLER_8_184 VDD VSS sg13g2_fill_1
X_2583_ _2583_/B _4893_/Q _2583_/A _2584_/B VDD VSS _2583_/D sg13g2_nand4_1
X_4322_ _4322_/RESET_B VSS VDD _4322_/D _4322_/Q _4397_/CLK sg13g2_dfrbpq_1
XFILLER_102_907 VDD VSS sg13g2_decap_8
XFILLER_114_756 VDD VSS sg13g2_fill_1
Xfanout108 _2850_/Y fanout108/X VDD VSS sg13g2_buf_1
Xfanout119 _2705_/Y _3553_/S VDD VSS sg13g2_buf_1
X_4253_ VSS VDD _4253_/A1 _4251_/X _4253_/Y _4252_/Y sg13g2_a21oi_1
X_3204_ _3204_/Y _3204_/A _3204_/B VDD VSS sg13g2_xnor2_1
X_4184_ VSS VDD _4188_/B1 _4183_/X _4184_/Y _4189_/B1 sg13g2_a21oi_1
XFILLER_55_504 VDD VSS sg13g2_decap_8
XFILLER_67_375 VDD VSS sg13g2_decap_8
XFILLER_83_813 VDD VSS sg13g2_decap_8
XFILLER_83_824 VDD VSS sg13g2_fill_2
X_3135_ _3134_/Y VDD _3135_/Y VSS _4628_/Q _3140_/B sg13g2_o21ai_1
X_3066_ _4088_/B _3066_/A1 _3083_/S _4492_/D VDD VSS sg13g2_mux2_1
XFILLER_94_194 VDD VSS sg13g2_decap_8
XFILLER_83_879 VDD VSS sg13g2_decap_4
XFILLER_23_401 VDD VSS sg13g2_decap_8
XFILLER_36_795 VDD VSS sg13g2_decap_8
XFILLER_51_710 VDD VSS sg13g2_decap_8
XFILLER_91_890 VDD VSS sg13g2_decap_8
XFILLER_35_294 VDD VSS sg13g2_decap_8
XFILLER_50_242 VDD VSS sg13g2_decap_8
X_3968_ _2630_/Y VDD _3976_/B VSS _4006_/B _4004_/A sg13g2_o21ai_1
X_2919_ _2919_/A0 _3101_/A0 _2928_/S _4351_/D VDD VSS sg13g2_mux2_1
XFILLER_12_35 VDD VSS sg13g2_decap_8
X_3899_ _3899_/A _3907_/B _3899_/C _3900_/B VDD VSS sg13g2_nor3_1
XFILLER_3_828 VDD VSS sg13g2_decap_8
XFILLER_2_316 VDD VSS sg13g2_decap_8
XFILLER_5_7 VDD VSS sg13g2_decap_8
XFILLER_86_640 VDD VSS sg13g2_decap_8
XFILLER_19_718 VDD VSS sg13g2_decap_8
XFILLER_37_21 VDD VSS sg13g2_decap_8
XFILLER_74_857 VDD VSS sg13g2_decap_8
XFILLER_26_261 VDD VSS sg13g2_decap_8
XFILLER_27_795 VDD VSS sg13g2_fill_2
XFILLER_41_242 VDD VSS sg13g2_decap_4
XFILLER_42_754 VDD VSS sg13g2_decap_8
XFILLER_42_765 VDD VSS sg13g2_fill_2
XFILLER_53_42 VDD VSS sg13g2_decap_8
XFILLER_14_489 VDD VSS sg13g2_fill_2
XFILLER_42_776 VDD VSS sg13g2_decap_8
X_4305__421 VDD VSS _4305_/RESET_B sg13g2_tiehi
XFILLER_115_509 VDD VSS sg13g2_decap_8
XFILLER_6_655 VDD VSS sg13g2_decap_8
XFILLER_2_883 VDD VSS sg13g2_decap_8
XFILLER_38_7 VDD VSS sg13g2_decap_8
XFILLER_96_426 VDD VSS sg13g2_decap_8
XFILLER_111_759 VDD VSS sg13g2_fill_1
XFILLER_77_651 VDD VSS sg13g2_decap_8
XFILLER_110_269 VDD VSS sg13g2_decap_8
XFILLER_76_150 VDD VSS sg13g2_decap_8
XFILLER_37_548 VDD VSS sg13g2_decap_8
X_4312__414 VDD VSS _4312_/RESET_B sg13g2_tiehi
XFILLER_80_827 VDD VSS sg13g2_decap_8
XFILLER_94_93 VDD VSS sg13g2_decap_8
XFILLER_18_773 VDD VSS sg13g2_decap_8
X_4940_ fanout334/X VSS VDD _4940_/D _4940_/Q _4941_/CLK sg13g2_dfrbpq_1
XFILLER_91_164 VDD VSS sg13g2_decap_8
XFILLER_17_294 VDD VSS sg13g2_decap_4
XFILLER_32_231 VDD VSS sg13g2_decap_8
X_4871_ fanout301/X VSS VDD _4871_/D _4871_/Q _4877_/CLK sg13g2_dfrbpq_1
X_3822_ _3822_/Y _3852_/A _3821_/Y _3828_/A2 _3415_/B VDD VSS sg13g2_a22oi_1
XFILLER_20_426 VDD VSS sg13g2_decap_4
X_3753_ _3753_/A _3764_/D _3753_/C _3753_/X VDD VSS sg13g2_or3_1
XFILLER_64_0 VDD VSS sg13g2_decap_8
X_3684_ _3706_/A _3698_/D _3717_/A _3688_/B VDD VSS _3684_/D sg13g2_nand4_1
X_2704_ _3596_/A _2704_/B _2710_/C VDD VSS sg13g2_nand2b_1
X_2635_ _2635_/Y _3977_/S _2635_/B VDD VSS sg13g2_nand2_1
XFILLER_0_809 VDD VSS sg13g2_decap_8
X_4305_ _4305_/RESET_B VSS VDD _4305_/D _4305_/Q _4971_/CLK sg13g2_dfrbpq_1
X_2566_ _2572_/B _4885_/Q _2566_/B VDD VSS sg13g2_nand2_1
X_2497_ _3574_/A _2692_/A _2648_/C _2703_/B _2498_/B VDD VSS sg13g2_nor4_1
XFILLER_87_437 VDD VSS sg13g2_decap_8
XFILLER_101_247 VDD VSS sg13g2_decap_8
X_4236_ _4236_/B1 VDD _4236_/Y VSS _4236_/A1 _4230_/X sg13g2_o21ai_1
XFILLER_87_448 VDD VSS sg13g2_fill_2
X_4167_ _4218_/A1 VDD _4167_/Y VSS _4165_/Y _4166_/Y sg13g2_o21ai_1
XFILLER_55_323 VDD VSS sg13g2_decap_8
XFILLER_67_183 VDD VSS sg13g2_decap_8
XFILLER_67_194 VDD VSS sg13g2_fill_1
X_3118_ _4645_/Q _3118_/A1 _3136_/B _3118_/X VDD VSS sg13g2_mux2_1
XFILLER_56_879 VDD VSS sg13g2_decap_8
X_4098_ VSS VDD _4199_/A1 _4097_/X _4098_/Y _2348_/A sg13g2_a21oi_1
XFILLER_82_164 VDD VSS sg13g2_decap_4
X_3049_ _3536_/A1 hold931/X _3051_/S _4475_/D VDD VSS sg13g2_mux2_1
XFILLER_12_916 VDD VSS sg13g2_decap_8
XFILLER_24_765 VDD VSS sg13g2_fill_2
XFILLER_51_595 VDD VSS sg13g2_decap_8
XFILLER_109_303 VDD VSS sg13g2_decap_8
XFILLER_23_89 VDD VSS sg13g2_decap_8
XFILLER_105_553 VDD VSS sg13g2_decap_8
XFILLER_105_597 VDD VSS sg13g2_fill_1
XFILLER_59_651 VDD VSS sg13g2_decap_8
XFILLER_0_49 VDD VSS sg13g2_decap_8
XFILLER_104_70 VDD VSS sg13g2_decap_8
XFILLER_47_879 VDD VSS sg13g2_decap_8
XFILLER_73_120 VDD VSS sg13g2_decap_8
XFILLER_74_676 VDD VSS sg13g2_fill_1
XFILLER_15_721 VDD VSS sg13g2_fill_1
XFILLER_61_315 VDD VSS sg13g2_decap_8
XFILLER_64_63 VDD VSS sg13g2_decap_8
XFILLER_14_220 VDD VSS sg13g2_fill_2
XFILLER_30_702 VDD VSS sg13g2_decap_8
XFILLER_42_573 VDD VSS sg13g2_fill_2
XFILLER_70_871 VDD VSS sg13g2_decap_8
XFILLER_9_14 VDD VSS sg13g2_decap_8
XFILLER_9_69 VDD VSS sg13g2_fill_2
XFILLER_80_84 VDD VSS sg13g2_decap_8
Xfanout90 fanout93/X _2954_/S VDD VSS sg13g2_buf_1
XFILLER_10_481 VDD VSS sg13g2_decap_4
Xhold909 _4322_/Q VDD VSS hold909/X sg13g2_dlygate4sd3_1
XFILLER_115_317 VDD VSS sg13g2_decap_8
XFILLER_6_496 VDD VSS sg13g2_decap_8
X_2420_ _2812_/B _2420_/A _2422_/C VDD VSS sg13g2_nand2_1
XFILLER_97_702 VDD VSS sg13g2_fill_1
XFILLER_69_404 VDD VSS sg13g2_decap_8
X_2351_ VDD _3712_/C _2351_/A VSS sg13g2_inv_1
X_2282_ VDD _2282_/Y _3461_/A VSS sg13g2_inv_1
XFILLER_97_746 VDD VSS sg13g2_decap_8
XFILLER_96_234 VDD VSS sg13g2_decap_8
Xhold1609 _4593_/Q VDD VSS _2596_/B sg13g2_dlygate4sd3_1
X_4021_ _4226_/S1 VDD _4021_/Y VSS _4250_/A1 _4437_/Q sg13g2_o21ai_1
XFILLER_37_323 VDD VSS sg13g2_fill_2
XFILLER_38_846 VDD VSS sg13g2_fill_1
XFILLER_25_507 VDD VSS sg13g2_decap_8
XFILLER_53_816 VDD VSS sg13g2_fill_1
XFILLER_65_654 VDD VSS sg13g2_decap_8
XFILLER_92_451 VDD VSS sg13g2_decap_4
XFILLER_92_473 VDD VSS sg13g2_decap_8
XFILLER_80_657 VDD VSS sg13g2_fill_2
X_4923_ fanout260/X VSS VDD _4923_/D _4923_/Q clkload5/A sg13g2_dfrbpq_1
XFILLER_100_28 VDD VSS sg13g2_fill_1
XFILLER_33_562 VDD VSS sg13g2_decap_8
XFILLER_61_871 VDD VSS sg13g2_decap_8
XFILLER_60_392 VDD VSS sg13g2_decap_8
X_4854_ fanout291/X VSS VDD _4854_/D _4854_/Q _4927_/CLK sg13g2_dfrbpq_1
XFILLER_20_234 VDD VSS sg13g2_decap_8
X_4785_ fanout250/X VSS VDD _4785_/D _4785_/Q clkload2/A sg13g2_dfrbpq_1
X_3805_ _4773_/Q _4774_/Q _4772_/Q _3851_/B _3805_/X VDD VSS sg13g2_or4_1
X_3736_ _4758_/Q _3792_/B _3735_/A _3737_/B VDD VSS sg13g2_a21o_1
XFILLER_107_818 VDD VSS sg13g2_decap_8
XFILLER_109_37 VDD VSS sg13g2_fill_1
XFILLER_106_317 VDD VSS sg13g2_decap_8
XFILLER_106_328 VDD VSS sg13g2_fill_2
XFILLER_109_59 VDD VSS sg13g2_fill_1
X_3667_ VSS VDD _3680_/B _3667_/B _4734_/Q sg13g2_or2_1
X_3598_ _4724_/D _3598_/A _3598_/B _3599_/B VDD VSS sg13g2_and3_1
X_2618_ _2618_/Y _2618_/A _3286_/B VDD VSS sg13g2_nand2_1
XFILLER_0_606 VDD VSS sg13g2_decap_8
X_2549_ _2549_/Y _2549_/A _2552_/B VDD VSS sg13g2_xnor2_1
XFILLER_88_713 VDD VSS sg13g2_fill_1
XFILLER_88_746 VDD VSS sg13g2_decap_8
XFILLER_87_245 VDD VSS sg13g2_decap_8
XFILLER_102_556 VDD VSS sg13g2_fill_2
XFILLER_75_407 VDD VSS sg13g2_decap_8
X_4219_ _4219_/Y _4219_/B _4218_/B1 VDD VSS sg13g2_nand2b_1
XFILLER_28_323 VDD VSS sg13g2_decap_4
XFILLER_18_56 VDD VSS sg13g2_decap_8
XFILLER_18_67 VDD VSS sg13g2_fill_1
XFILLER_29_868 VDD VSS sg13g2_decap_8
XFILLER_56_643 VDD VSS sg13g2_decap_8
XFILLER_56_654 VDD VSS sg13g2_fill_1
XFILLER_43_315 VDD VSS sg13g2_decap_8
XFILLER_71_657 VDD VSS sg13g2_decap_8
XFILLER_12_702 VDD VSS sg13g2_decap_8
XFILLER_24_562 VDD VSS sg13g2_fill_1
XFILLER_34_44 VDD VSS sg13g2_decap_4
XFILLER_70_156 VDD VSS sg13g2_decap_8
XFILLER_34_88 VDD VSS sg13g2_fill_2
XFILLER_11_256 VDD VSS sg13g2_decap_4
XFILLER_11_289 VDD VSS sg13g2_decap_8
XFILLER_7_216 VDD VSS sg13g2_decap_8
X_4302__424 VDD VSS _4302_/RESET_B sg13g2_tiehi
XFILLER_106_895 VDD VSS sg13g2_decap_8
XFILLER_59_41 VDD VSS sg13g2_decap_8
XFILLER_78_201 VDD VSS sg13g2_decap_8
XFILLER_79_735 VDD VSS sg13g2_decap_8
XFILLER_94_716 VDD VSS sg13g2_decap_8
XFILLER_115_80 VDD VSS sg13g2_decap_4
Xfanout280 fanout283/X fanout280/X VDD VSS sg13g2_buf_1
Xfanout291 fanout294/X fanout291/X VDD VSS sg13g2_buf_1
XFILLER_75_51 VDD VSS sg13g2_decap_8
XFILLER_93_259 VDD VSS sg13g2_decap_8
XFILLER_47_698 VDD VSS sg13g2_fill_2
XFILLER_75_84 VDD VSS sg13g2_decap_8
XFILLER_90_911 VDD VSS sg13g2_decap_8
XFILLER_46_197 VDD VSS sg13g2_decap_4
XFILLER_50_808 VDD VSS sg13g2_decap_8
XFILLER_61_112 VDD VSS sg13g2_decap_4
XFILLER_62_679 VDD VSS sg13g2_fill_1
X_4570_ fanout329/X VSS VDD _4570_/D _4570_/Q _4580_/CLK sg13g2_dfrbpq_1
X_3521_ _3522_/A _3522_/C _3572_/A VDD VSS sg13g2_nor2_1
XFILLER_115_103 VDD VSS sg13g2_decap_8
XFILLER_116_648 VDD VSS sg13g2_decap_8
XFILLER_6_260 VDD VSS sg13g2_fill_1
XFILLER_7_783 VDD VSS sg13g2_decap_8
Xhold728 _3931_/Y VDD VSS _3932_/B sg13g2_dlygate4sd3_1
Xhold717 _2542_/X VDD VSS _4875_/D sg13g2_dlygate4sd3_1
Xhold706 _4839_/Q VDD VSS _2234_/A sg13g2_dlygate4sd3_1
Xhold739 _3881_/Y VDD VSS _4803_/D sg13g2_dlygate4sd3_1
X_3452_ _3451_/Y VDD _4663_/D VSS _2269_/Y _3453_/C sg13g2_o21ai_1
X_3383_ _4788_/Q _3413_/C _3405_/C VDD VSS sg13g2_nor2_1
X_2403_ VSS VDD _2358_/Y _2401_/X _2792_/B _2402_/Y sg13g2_a21oi_1
XFILLER_112_854 VDD VSS sg13g2_decap_8
X_2334_ VDD _3506_/A _3504_/A VSS sg13g2_inv_1
XFILLER_97_532 VDD VSS sg13g2_decap_8
XFILLER_111_331 VDD VSS sg13g2_fill_2
XFILLER_111_364 VDD VSS sg13g2_decap_8
XFILLER_27_0 VDD VSS sg13g2_decap_8
Xhold1406 _4905_/Q VDD VSS _2792_/A sg13g2_dlygate4sd3_1
XFILLER_85_727 VDD VSS sg13g2_decap_8
XFILLER_38_610 VDD VSS sg13g2_fill_2
Xhold1417 _4793_/Q VDD VSS _3856_/A1 sg13g2_dlygate4sd3_1
Xhold1428 _4527_/Q VDD VSS hold1428/X sg13g2_dlygate4sd3_1
Xhold1439 _4919_/Q VDD VSS _2425_/A sg13g2_dlygate4sd3_1
X_2265_ VDD _2265_/Y _3445_/A VSS sg13g2_inv_1
XFILLER_37_142 VDD VSS sg13g2_decap_8
XFILLER_38_643 VDD VSS sg13g2_fill_2
XFILLER_65_451 VDD VSS sg13g2_fill_2
XFILLER_84_259 VDD VSS sg13g2_decap_4
X_4004_ _4004_/Y _4004_/A _4004_/B VDD VSS sg13g2_nand2_1
XFILLER_53_602 VDD VSS sg13g2_decap_4
XFILLER_65_484 VDD VSS sg13g2_decap_4
XFILLER_111_49 VDD VSS sg13g2_decap_8
XFILLER_41_808 VDD VSS sg13g2_fill_1
XFILLER_80_465 VDD VSS sg13g2_decap_8
XFILLER_33_381 VDD VSS sg13g2_decap_8
XFILLER_40_318 VDD VSS sg13g2_decap_8
X_4906_ fanout259/X VSS VDD _4906_/D _4906_/Q _4907_/CLK sg13g2_dfrbpq_1
XFILLER_21_532 VDD VSS sg13g2_decap_4
X_4837_ fanout269/X VSS VDD _4837_/D _4837_/Q _4841_/CLK sg13g2_dfrbpq_1
XFILLER_21_598 VDD VSS sg13g2_fill_2
X_4768_ fanout246/X VSS VDD _4768_/D _4768_/Q clkload1/A sg13g2_dfrbpq_1
XFILLER_4_219 VDD VSS sg13g2_decap_8
X_4699_ fanout309/X VSS VDD _4699_/D _4699_/Q _4894_/CLK sg13g2_dfrbpq_1
X_3719_ _3719_/A _3719_/B _3719_/C _3719_/X VDD VSS sg13g2_or3_1
XFILLER_105_7 VDD VSS sg13g2_fill_1
XFILLER_20_35 VDD VSS sg13g2_decap_8
XFILLER_0_403 VDD VSS sg13g2_decap_8
XFILLER_1_915 VDD VSS sg13g2_decap_8
XFILLER_114_180 VDD VSS sg13g2_fill_2
XFILLER_96_28 VDD VSS sg13g2_fill_1
XFILLER_102_342 VDD VSS sg13g2_decap_8
XFILLER_88_565 VDD VSS sg13g2_decap_8
XFILLER_29_610 VDD VSS sg13g2_decap_8
XFILLER_75_204 VDD VSS sg13g2_decap_4
XFILLER_75_215 VDD VSS sg13g2_decap_8
XFILLER_75_226 VDD VSS sg13g2_fill_2
XFILLER_88_587 VDD VSS sg13g2_decap_8
XFILLER_29_99 VDD VSS sg13g2_fill_1
XFILLER_29_687 VDD VSS sg13g2_decap_8
XFILLER_44_624 VDD VSS sg13g2_decap_8
XFILLER_45_21 VDD VSS sg13g2_decap_8
XFILLER_56_462 VDD VSS sg13g2_decap_4
XFILLER_72_922 VDD VSS sg13g2_decap_4
XFILLER_45_32 VDD VSS sg13g2_fill_1
XFILLER_71_432 VDD VSS sg13g2_decap_8
XFILLER_83_270 VDD VSS sg13g2_decap_8
XFILLER_25_860 VDD VSS sg13g2_decap_8
XFILLER_43_167 VDD VSS sg13g2_decap_8
XFILLER_45_98 VDD VSS sg13g2_fill_2
XFILLER_71_465 VDD VSS sg13g2_decap_8
XFILLER_40_830 VDD VSS sg13g2_fill_2
XFILLER_101_82 VDD VSS sg13g2_decap_8
XFILLER_24_392 VDD VSS sg13g2_decap_8
XFILLER_61_42 VDD VSS sg13g2_decap_8
XFILLER_8_536 VDD VSS sg13g2_decap_8
XFILLER_4_753 VDD VSS sg13g2_decap_8
XFILLER_113_607 VDD VSS sg13g2_decap_4
XFILLER_113_618 VDD VSS sg13g2_fill_1
XFILLER_105_180 VDD VSS sg13g2_decap_8
XFILLER_106_681 VDD VSS sg13g2_decap_8
XFILLER_3_296 VDD VSS sg13g2_decap_8
XFILLER_79_576 VDD VSS sg13g2_decap_8
XFILLER_94_502 VDD VSS sg13g2_fill_2
XFILLER_20_7 VDD VSS sg13g2_decap_8
XFILLER_67_738 VDD VSS sg13g2_decap_4
XFILLER_82_719 VDD VSS sg13g2_decap_8
XFILLER_75_771 VDD VSS sg13g2_decap_8
XFILLER_19_186 VDD VSS sg13g2_fill_2
XFILLER_34_123 VDD VSS sg13g2_decap_8
XFILLER_35_657 VDD VSS sg13g2_decap_8
XFILLER_47_495 VDD VSS sg13g2_fill_1
XFILLER_74_292 VDD VSS sg13g2_decap_8
XFILLER_16_860 VDD VSS sg13g2_decap_8
XFILLER_22_307 VDD VSS sg13g2_decap_8
XFILLER_23_808 VDD VSS sg13g2_decap_4
XFILLER_62_465 VDD VSS sg13g2_decap_8
XFILLER_15_370 VDD VSS sg13g2_decap_4
XFILLER_34_189 VDD VSS sg13g2_decap_8
X_2952_ hold963/X _3107_/A0 _2955_/S _4382_/D VDD VSS sg13g2_mux2_1
X_2883_ _2883_/A0 _3091_/A0 _2901_/S _2883_/X VDD VSS sg13g2_mux2_1
X_4622_ fanout278/X VSS VDD _4622_/D _4622_/Q _4950_/CLK sg13g2_dfrbpq_1
XFILLER_116_401 VDD VSS sg13g2_decap_8
X_4553_ fanout286/X VSS VDD _4553_/D _4553_/Q _4927_/CLK sg13g2_dfrbpq_1
XFILLER_7_591 VDD VSS sg13g2_decap_8
X_4484_ fanout321/X VSS VDD _4484_/D _4484_/Q _4869_/CLK sg13g2_dfrbpq_1
X_3504_ _3504_/B _3504_/C _3504_/A _3504_/Y VDD VSS sg13g2_nand3_1
Xhold547 _4896_/Q VDD VSS _2470_/B sg13g2_dlygate4sd3_1
Xhold558 _2764_/Y VDD VSS _4934_/D sg13g2_dlygate4sd3_1
Xhold569 _2558_/Y VDD VSS _4882_/D sg13g2_dlygate4sd3_1
X_3435_ _3453_/B _3471_/C _3435_/A _3435_/Y VDD VSS sg13g2_nand3_1
X_3366_ _3463_/A _3649_/A _3368_/S _4642_/D VDD VSS sg13g2_mux2_1
XFILLER_58_749 VDD VSS sg13g2_decap_8
Xhold1203 _4305_/Q VDD VSS _2870_/A0 sg13g2_dlygate4sd3_1
Xhold1214 _4361_/Q VDD VSS _2931_/A0 sg13g2_dlygate4sd3_1
Xhold1225 _4403_/Q VDD VSS _2974_/A0 sg13g2_dlygate4sd3_1
X_3297_ _3297_/A0 _4626_/Q _3368_/S _3297_/X VDD VSS sg13g2_mux2_1
X_2317_ VDD _3385_/A _2317_/A VSS sg13g2_inv_1
XFILLER_100_868 VDD VSS sg13g2_decap_8
XFILLER_111_183 VDD VSS sg13g2_fill_2
Xhold1236 _3188_/Y VDD VSS _3190_/A1 sg13g2_dlygate4sd3_1
Xhold1247 _2827_/X VDD VSS _4264_/D sg13g2_dlygate4sd3_1
Xhold1258 _3124_/X VDD VSS _4548_/D sg13g2_dlygate4sd3_1
X_2248_ VDD _3928_/A _3935_/B VSS sg13g2_inv_1
XFILLER_85_568 VDD VSS sg13g2_decap_8
XFILLER_26_602 VDD VSS sg13g2_fill_1
Xhold1269 _3537_/X VDD VSS _4699_/D sg13g2_dlygate4sd3_1
XFILLER_25_123 VDD VSS sg13g2_decap_8
XFILLER_13_307 VDD VSS sg13g2_decap_8
XFILLER_14_819 VDD VSS sg13g2_decap_8
XFILLER_80_251 VDD VSS sg13g2_fill_2
XFILLER_13_318 VDD VSS sg13g2_fill_1
XFILLER_25_178 VDD VSS sg13g2_decap_8
XFILLER_53_487 VDD VSS sg13g2_fill_2
XFILLER_22_863 VDD VSS sg13g2_decap_8
XFILLER_80_295 VDD VSS sg13g2_decap_8
XFILLER_108_924 VDD VSS sg13g2_fill_2
XFILLER_107_478 VDD VSS sg13g2_decap_8
Xoutput12 _5180_/X ld1 VDD VSS sg13g2_buf_1
XFILLER_1_712 VDD VSS sg13g2_decap_8
XFILLER_49_716 VDD VSS sg13g2_decap_8
XFILLER_89_852 VDD VSS sg13g2_decap_8
XFILLER_88_340 VDD VSS sg13g2_decap_4
XFILLER_0_266 VDD VSS sg13g2_decap_8
XFILLER_1_789 VDD VSS sg13g2_decap_8
XFILLER_76_513 VDD VSS sg13g2_fill_2
XFILLER_56_31 VDD VSS sg13g2_fill_1
XFILLER_76_546 VDD VSS sg13g2_decap_8
XFILLER_29_451 VDD VSS sg13g2_decap_8
XFILLER_56_42 VDD VSS sg13g2_decap_8
XFILLER_63_218 VDD VSS sg13g2_decap_8
XFILLER_16_101 VDD VSS sg13g2_decap_8
XFILLER_16_123 VDD VSS sg13g2_decap_8
XFILLER_29_495 VDD VSS sg13g2_decap_8
XFILLER_72_730 VDD VSS sg13g2_decap_8
XFILLER_44_498 VDD VSS sg13g2_decap_8
XFILLER_13_896 VDD VSS sg13g2_decap_8
XFILLER_9_856 VDD VSS sg13g2_decap_8
XFILLER_68_7 VDD VSS sg13g2_fill_1
XFILLER_4_561 VDD VSS sg13g2_decap_4
XFILLER_99_649 VDD VSS sg13g2_fill_1
X_3220_ _3220_/A _3219_/Y _3221_/B VDD VSS sg13g2_nor2b_1
XFILLER_98_148 VDD VSS sg13g2_decap_4
XFILLER_100_109 VDD VSS sg13g2_decap_8
XFILLER_39_204 VDD VSS sg13g2_decap_8
X_3151_ VSS VDD _3151_/A1 _3150_/Y _3151_/Y _3185_/A sg13g2_a21oi_1
XFILLER_67_546 VDD VSS sg13g2_decap_8
XFILLER_79_395 VDD VSS sg13g2_decap_4
XFILLER_95_877 VDD VSS sg13g2_fill_1
XFILLER_95_866 VDD VSS sg13g2_decap_8
XFILLER_36_900 VDD VSS sg13g2_decap_8
XFILLER_82_516 VDD VSS sg13g2_fill_2
X_3082_ _4228_/B _3082_/A1 _3082_/S _4506_/D VDD VSS sg13g2_mux2_1
XFILLER_94_365 VDD VSS sg13g2_decap_8
XFILLER_94_354 VDD VSS sg13g2_fill_2
XFILLER_51_914 VDD VSS sg13g2_decap_8
XFILLER_90_560 VDD VSS sg13g2_fill_1
XFILLER_51_925 VDD VSS sg13g2_fill_1
XFILLER_50_435 VDD VSS sg13g2_fill_1
X_3984_ VSS VDD _3987_/A _4834_/Q _3984_/Y _3983_/Y sg13g2_a21oi_1
XFILLER_94_0 VDD VSS sg13g2_decap_8
XFILLER_50_468 VDD VSS sg13g2_decap_4
X_2935_ _4052_/B _3090_/A0 _2955_/S _2935_/X VDD VSS sg13g2_mux2_1
X_2866_ _2866_/A0 _3101_/A0 _2869_/S _4301_/D VDD VSS sg13g2_mux2_1
X_4605_ fanout277/X VSS VDD _4605_/D _4605_/Q _4950_/CLK sg13g2_dfrbpq_1
X_2797_ _2807_/A _2798_/B _2797_/C _2797_/Y VDD VSS sg13g2_nor3_1
XFILLER_116_242 VDD VSS sg13g2_decap_8
X_4536_ fanout284/X VSS VDD _4536_/D _4536_/Q _4559_/CLK sg13g2_dfrbpq_1
X_4467_ fanout301/X VSS VDD _4467_/D _4467_/Q _4974_/CLK sg13g2_dfrbpq_1
XFILLER_89_126 VDD VSS sg13g2_fill_2
X_4398_ _4398_/RESET_B VSS VDD _4398_/D _4398_/Q _4975_/CLK sg13g2_dfrbpq_1
X_3418_ _3417_/Y VDD _3420_/C VSS _3337_/D _3416_/Y sg13g2_o21ai_1
XFILLER_100_610 VDD VSS sg13g2_decap_8
XFILLER_58_513 VDD VSS sg13g2_decap_8
Xhold1000 _4511_/Q VDD VSS _3011_/A1 sg13g2_dlygate4sd3_1
X_3349_ _3469_/C _3360_/B _3350_/C VDD VSS sg13g2_and2_1
XFILLER_98_693 VDD VSS sg13g2_decap_4
XFILLER_85_332 VDD VSS sg13g2_decap_8
Xhold1011 _4334_/Q VDD VSS _2901_/A0 sg13g2_dlygate4sd3_1
Xhold1022 _4359_/Q VDD VSS _2927_/A0 sg13g2_dlygate4sd3_1
Xhold1033 _4432_/Q VDD VSS _3005_/A0 sg13g2_dlygate4sd3_1
XFILLER_86_855 VDD VSS sg13g2_decap_8
XFILLER_27_911 VDD VSS sg13g2_decap_8
XFILLER_45_207 VDD VSS sg13g2_fill_2
XFILLER_73_527 VDD VSS sg13g2_decap_8
Xhold1044 _4551_/Q VDD VSS _3127_/A1 sg13g2_dlygate4sd3_1
Xhold1055 _4494_/Q VDD VSS _3069_/A1 sg13g2_dlygate4sd3_1
Xhold1066 _4468_/Q VDD VSS _3553_/A1 sg13g2_dlygate4sd3_1
XFILLER_93_18 VDD VSS sg13g2_fill_1
XFILLER_85_387 VDD VSS sg13g2_decap_8
Xhold1077 _4317_/Q VDD VSS _2884_/A0 sg13g2_dlygate4sd3_1
Xhold1088 _2875_/X VDD VSS _4310_/D sg13g2_dlygate4sd3_1
Xhold1099 _2895_/X VDD VSS _4328_/D sg13g2_dlygate4sd3_1
XFILLER_26_89 VDD VSS sg13g2_fill_1
XFILLER_53_284 VDD VSS sg13g2_decap_8
XFILLER_13_126 VDD VSS sg13g2_decap_4
XFILLER_53_295 VDD VSS sg13g2_fill_2
XFILLER_22_682 VDD VSS sg13g2_decap_8
XFILLER_10_888 VDD VSS sg13g2_decap_8
XFILLER_6_826 VDD VSS sg13g2_decap_8
XFILLER_107_253 VDD VSS sg13g2_decap_8
XFILLER_108_787 VDD VSS sg13g2_decap_8
XFILLER_1_531 VDD VSS sg13g2_decap_8
XFILLER_1_575 VDD VSS sg13g2_decap_4
XFILLER_3_49 VDD VSS sg13g2_fill_2
XFILLER_77_811 VDD VSS sg13g2_fill_1
XFILLER_1_597 VDD VSS sg13g2_decap_8
XFILLER_49_557 VDD VSS sg13g2_fill_2
XFILLER_67_63 VDD VSS sg13g2_decap_8
XFILLER_45_730 VDD VSS sg13g2_decap_8
XFILLER_64_527 VDD VSS sg13g2_decap_8
XFILLER_76_387 VDD VSS sg13g2_decap_8
XFILLER_92_847 VDD VSS sg13g2_fill_1
XFILLER_91_368 VDD VSS sg13g2_decap_8
XFILLER_32_413 VDD VSS sg13g2_fill_1
XFILLER_33_925 VDD VSS sg13g2_fill_1
XFILLER_32_479 VDD VSS sg13g2_decap_8
XFILLER_40_490 VDD VSS sg13g2_fill_2
X_2720_ _3977_/S _4842_/Q _4004_/B VDD VSS sg13g2_nor2_1
X_2651_ _4720_/Q _3588_/A _2651_/A _2692_/B VDD VSS _4723_/Q sg13g2_nand4_1
X_2582_ _4893_/D _2582_/A _2582_/B VDD VSS sg13g2_xnor2_1
XFILLER_113_223 VDD VSS sg13g2_decap_4
XFILLER_114_735 VDD VSS sg13g2_decap_8
X_4321_ _4321_/RESET_B VSS VDD _4321_/D _4321_/Q _4973_/CLK sg13g2_dfrbpq_1
XFILLER_114_768 VDD VSS sg13g2_fill_1
Xfanout109 fanout113/X _2846_/S VDD VSS sg13g2_buf_1
X_4252_ _4254_/A1 VDD _4252_/Y VSS _4249_/Y _4250_/Y sg13g2_o21ai_1
XFILLER_113_267 VDD VSS sg13g2_fill_2
XFILLER_68_811 VDD VSS sg13g2_decap_8
X_3203_ _2645_/A VDD _4585_/D VSS _3193_/B _3203_/A2 sg13g2_o21ai_1
XFILLER_79_181 VDD VSS sg13g2_decap_8
X_4183_ _4278_/Q _4303_/Q _4186_/S _4183_/X VDD VSS sg13g2_mux2_1
XFILLER_28_708 VDD VSS sg13g2_fill_1
XFILLER_67_354 VDD VSS sg13g2_fill_1
X_3134_ _3134_/Y _3134_/A _3140_/B VDD VSS sg13g2_nand2_1
XFILLER_103_28 VDD VSS sg13g2_decap_8
XFILLER_103_39 VDD VSS sg13g2_fill_2
XFILLER_83_858 VDD VSS sg13g2_decap_8
X_3065_ _4079_/B hold796/X _3085_/S _4491_/D VDD VSS sg13g2_mux2_1
XFILLER_36_774 VDD VSS sg13g2_decap_8
XFILLER_23_424 VDD VSS sg13g2_fill_1
XFILLER_51_755 VDD VSS sg13g2_decap_8
XFILLER_23_468 VDD VSS sg13g2_decap_8
XFILLER_23_479 VDD VSS sg13g2_fill_1
X_3967_ _3966_/Y VDD _4827_/D VSS _2348_/Y _4848_/D sg13g2_o21ai_1
XFILLER_10_129 VDD VSS sg13g2_decap_8
X_2918_ _2918_/A0 _3100_/A0 _2926_/S _2918_/X VDD VSS sg13g2_mux2_1
XFILLER_109_529 VDD VSS sg13g2_decap_8
XFILLER_12_14 VDD VSS sg13g2_decap_8
Xclkbuf_leaf_30_clk clkbuf_4_15_0_clk/X _4580_/CLK VDD VSS sg13g2_buf_8
X_3898_ VSS VDD _3905_/C _3895_/Y _3900_/A _2245_/Y sg13g2_a21oi_1
X_2849_ _4794_/Q _2849_/C _4856_/Q _3009_/A VDD VSS sg13g2_nand3_1
XFILLER_105_702 VDD VSS sg13g2_decap_4
XFILLER_3_807 VDD VSS sg13g2_decap_8
X_4519_ fanout287/X VSS VDD _4519_/D _4519_/Q _4552_/CLK sg13g2_dfrbpq_1
XFILLER_78_619 VDD VSS sg13g2_fill_1
XFILLER_104_267 VDD VSS sg13g2_decap_8
XFILLER_59_811 VDD VSS sg13g2_decap_8
XFILLER_59_822 VDD VSS sg13g2_fill_2
XFILLER_86_630 VDD VSS sg13g2_fill_1
XFILLER_86_652 VDD VSS sg13g2_fill_2
XFILLER_46_538 VDD VSS sg13g2_decap_8
XFILLER_86_696 VDD VSS sg13g2_decap_4
XFILLER_37_77 VDD VSS sg13g2_decap_8
XFILLER_37_88 VDD VSS sg13g2_fill_2
XFILLER_27_774 VDD VSS sg13g2_decap_8
XFILLER_54_560 VDD VSS sg13g2_decap_4
XFILLER_53_21 VDD VSS sg13g2_decap_8
XFILLER_81_390 VDD VSS sg13g2_decap_8
XFILLER_14_457 VDD VSS sg13g2_fill_1
Xclkbuf_leaf_21_clk clkbuf_4_6_0_clk/X _4552_/CLK VDD VSS sg13g2_buf_8
XFILLER_6_634 VDD VSS sg13g2_decap_8
XFILLER_5_177 VDD VSS sg13g2_fill_1
XFILLER_78_51 VDD VSS sg13g2_decap_8
XFILLER_2_862 VDD VSS sg13g2_decap_8
XFILLER_96_405 VDD VSS sg13g2_decap_8
XFILLER_104_790 VDD VSS sg13g2_fill_2
XFILLER_1_394 VDD VSS sg13g2_decap_8
XFILLER_49_332 VDD VSS sg13g2_decap_8
XFILLER_77_630 VDD VSS sg13g2_decap_8
XFILLER_37_527 VDD VSS sg13g2_decap_8
XFILLER_94_72 VDD VSS sg13g2_fill_1
XFILLER_94_61 VDD VSS sg13g2_decap_8
XFILLER_65_869 VDD VSS sg13g2_decap_8
XFILLER_80_806 VDD VSS sg13g2_decap_8
XFILLER_92_655 VDD VSS sg13g2_decap_8
XFILLER_91_143 VDD VSS sg13g2_decap_8
XFILLER_17_240 VDD VSS sg13g2_decap_8
XFILLER_17_273 VDD VSS sg13g2_decap_4
XFILLER_64_379 VDD VSS sg13g2_decap_8
XFILLER_73_891 VDD VSS sg13g2_fill_2
XFILLER_32_210 VDD VSS sg13g2_decap_8
X_4870_ fanout326/X VSS VDD _4870_/D _4870_/Q _4870_/CLK sg13g2_dfrbpq_1
XFILLER_20_405 VDD VSS sg13g2_decap_8
XFILLER_21_917 VDD VSS sg13g2_decap_8
X_3821_ _3821_/Y _3827_/A _3821_/B VDD VSS sg13g2_nand2_1
XFILLER_20_449 VDD VSS sg13g2_decap_8
XFILLER_32_287 VDD VSS sg13g2_fill_1
Xclkbuf_leaf_12_clk clkbuf_4_4_0_clk/X _4942_/CLK VDD VSS sg13g2_buf_8
X_3752_ VSS VDD _3749_/A _3751_/C _3753_/C _3751_/B sg13g2_a21oi_1
XFILLER_9_450 VDD VSS sg13g2_decap_4
X_3683_ _4747_/Q VDD _3684_/D VSS _4746_/Q _3717_/B sg13g2_o21ai_1
X_2703_ _2703_/A _2703_/B _2703_/C _2710_/C VDD VSS sg13g2_nor3_1
XFILLER_9_494 VDD VSS sg13g2_fill_2
X_2634_ _2634_/B _3972_/C _2634_/A _2634_/Y VDD VSS _3972_/D sg13g2_nand4_1
XFILLER_57_0 VDD VSS sg13g2_decap_8
X_2565_ VSS VDD _4885_/Q _2563_/B _2565_/Y _2566_/B sg13g2_a21oi_1
XFILLER_114_554 VDD VSS sg13g2_decap_8
X_4304_ _4304_/RESET_B VSS VDD _4304_/D _4304_/Q _4927_/CLK sg13g2_dfrbpq_1
X_2496_ _2651_/A _4720_/Q _3587_/C _4723_/Q _2703_/B VDD VSS sg13g2_or4_1
XFILLER_102_749 VDD VSS sg13g2_decap_8
XFILLER_4_81 VDD VSS sg13g2_fill_1
X_4235_ VSS VDD _4244_/A1 _4233_/X _4235_/Y _4234_/Y sg13g2_a21oi_1
XFILLER_114_27 VDD VSS sg13g2_fill_1
XFILLER_83_600 VDD VSS sg13g2_decap_8
X_4166_ _4253_/A1 VDD _4166_/Y VSS _4250_/A1 _4401_/Q sg13g2_o21ai_1
XFILLER_55_302 VDD VSS sg13g2_decap_8
XFILLER_56_858 VDD VSS sg13g2_decap_8
XFILLER_67_162 VDD VSS sg13g2_decap_8
XFILLER_82_110 VDD VSS sg13g2_decap_4
X_3117_ _3652_/A1 _3117_/A1 _3128_/B _4541_/D VDD VSS sg13g2_mux2_1
XFILLER_43_508 VDD VSS sg13g2_decap_8
XFILLER_82_143 VDD VSS sg13g2_decap_8
XFILLER_83_677 VDD VSS sg13g2_decap_8
X_4097_ _4269_/Q _4294_/Q _4197_/S _4097_/X VDD VSS sg13g2_mux2_1
XFILLER_55_379 VDD VSS sg13g2_decap_8
XFILLER_64_880 VDD VSS sg13g2_decap_8
X_3048_ _3535_/A1 _3075_/A1 _3056_/S _4474_/D VDD VSS sg13g2_mux2_1
XFILLER_24_744 VDD VSS sg13g2_decap_8
XFILLER_36_593 VDD VSS sg13g2_decap_8
XFILLER_64_891 VDD VSS sg13g2_fill_2
XFILLER_23_243 VDD VSS sg13g2_decap_8
XFILLER_24_777 VDD VSS sg13g2_fill_2
XFILLER_51_574 VDD VSS sg13g2_decap_8
XFILLER_99_17 VDD VSS sg13g2_fill_1
XFILLER_109_359 VDD VSS sg13g2_decap_8
XFILLER_3_648 VDD VSS sg13g2_fill_2
XFILLER_101_771 VDD VSS sg13g2_decap_8
XFILLER_101_782 VDD VSS sg13g2_fill_1
XFILLER_19_527 VDD VSS sg13g2_fill_2
XFILLER_48_87 VDD VSS sg13g2_fill_1
XFILLER_0_28 VDD VSS sg13g2_decap_8
XFILLER_46_346 VDD VSS sg13g2_decap_8
XFILLER_46_357 VDD VSS sg13g2_fill_1
XFILLER_47_858 VDD VSS sg13g2_decap_8
XFILLER_64_42 VDD VSS sg13g2_decap_8
XFILLER_27_582 VDD VSS sg13g2_decap_8
XFILLER_54_390 VDD VSS sg13g2_decap_8
XFILLER_73_187 VDD VSS sg13g2_decap_8
XFILLER_73_198 VDD VSS sg13g2_fill_2
XFILLER_15_788 VDD VSS sg13g2_fill_1
XFILLER_42_552 VDD VSS sg13g2_decap_8
XFILLER_9_48 VDD VSS sg13g2_decap_8
XFILLER_9_37 VDD VSS sg13g2_fill_2
XFILLER_30_758 VDD VSS sg13g2_decap_8
XFILLER_80_63 VDD VSS sg13g2_decap_8
Xfanout80 _3007_/S _3003_/S VDD VSS sg13g2_buf_1
Xfanout91 fanout93/X _2955_/S VDD VSS sg13g2_buf_1
XFILLER_10_460 VDD VSS sg13g2_decap_8
XFILLER_7_921 VDD VSS sg13g2_decap_4
XFILLER_50_7 VDD VSS sg13g2_fill_1
XFILLER_6_475 VDD VSS sg13g2_decap_8
XFILLER_89_50 VDD VSS sg13g2_decap_8
X_2350_ VDD _3690_/A _4743_/Q VSS sg13g2_inv_1
XFILLER_111_535 VDD VSS sg13g2_decap_8
X_2281_ VDD _2281_/Y _4677_/Q VSS sg13g2_inv_1
XFILLER_96_213 VDD VSS sg13g2_decap_8
Xclkbuf_leaf_1_clk clkbuf_4_1_0_clk/X clkload2/A VDD VSS sg13g2_buf_8
X_4020_ _4052_/A _4412_/Q _4020_/Y VDD VSS sg13g2_nor2_1
XFILLER_37_302 VDD VSS sg13g2_decap_8
XFILLER_65_611 VDD VSS sg13g2_decap_4
XFILLER_65_633 VDD VSS sg13g2_decap_8
XFILLER_77_482 VDD VSS sg13g2_decap_8
XFILLER_93_920 VDD VSS sg13g2_decap_4
XFILLER_92_430 VDD VSS sg13g2_decap_8
XFILLER_18_571 VDD VSS sg13g2_decap_4
XFILLER_52_305 VDD VSS sg13g2_decap_4
XFILLER_80_614 VDD VSS sg13g2_fill_1
XFILLER_33_530 VDD VSS sg13g2_fill_1
XFILLER_45_390 VDD VSS sg13g2_decap_8
XFILLER_52_327 VDD VSS sg13g2_fill_2
X_4922_ fanout262/X VSS VDD _4922_/D _4922_/Q clkload5/A sg13g2_dfrbpq_1
XFILLER_61_850 VDD VSS sg13g2_fill_1
X_4853_ fanout315/X VSS VDD _4853_/D _4853_/Q _4929_/CLK sg13g2_dfrbpq_1
X_4784_ fanout250/X VSS VDD _4784_/D _4784_/Q clkload0/A sg13g2_dfrbpq_1
X_3804_ _4772_/Q _3851_/B _3850_/B VDD VSS sg13g2_nor2_1
X_3735_ _3735_/Y _3735_/A _3758_/B VDD VSS sg13g2_nand2_1
XFILLER_9_280 VDD VSS sg13g2_decap_8
X_3666_ _4737_/Q VDD _3667_/B VSS _4736_/Q _4735_/Q sg13g2_o21ai_1
X_3597_ _3599_/B _3597_/A _3597_/B VDD VSS sg13g2_nand2_1
X_2617_ _3280_/A _2617_/B _3280_/B _3286_/B VDD VSS sg13g2_nor3_1
XFILLER_115_863 VDD VSS sg13g2_decap_8
X_2548_ _2552_/A _2552_/B _2550_/B VDD VSS sg13g2_nor2_1
XFILLER_88_725 VDD VSS sg13g2_decap_8
XFILLER_114_395 VDD VSS sg13g2_fill_1
XFILLER_87_224 VDD VSS sg13g2_decap_8
X_4218_ _4218_/B1 VDD _4218_/Y VSS _4218_/A1 _4212_/X sg13g2_o21ai_1
X_2479_ _3936_/A _4814_/Q _3925_/A VDD VSS sg13g2_nand2_1
XFILLER_18_35 VDD VSS sg13g2_decap_8
XFILLER_29_847 VDD VSS sg13g2_decap_8
XFILLER_56_622 VDD VSS sg13g2_decap_8
XFILLER_84_920 VDD VSS sg13g2_decap_4
XFILLER_96_791 VDD VSS sg13g2_decap_8
XFILLER_68_493 VDD VSS sg13g2_decap_8
XFILLER_83_430 VDD VSS sg13g2_fill_1
XFILLER_83_441 VDD VSS sg13g2_decap_8
X_4149_ _4148_/Y VDD _4968_/D VSS _4146_/Y _4147_/Y sg13g2_o21ai_1
XFILLER_44_839 VDD VSS sg13g2_decap_8
XFILLER_56_699 VDD VSS sg13g2_decap_8
XFILLER_71_603 VDD VSS sg13g2_decap_8
XFILLER_24_541 VDD VSS sg13g2_fill_1
XFILLER_52_861 VDD VSS sg13g2_fill_1
XFILLER_11_235 VDD VSS sg13g2_decap_8
Xclkload0 clkload0/A clkload0/X VDD VSS sg13g2_buf_8
XFILLER_109_134 VDD VSS sg13g2_decap_4
XFILLER_106_874 VDD VSS sg13g2_decap_8
XFILLER_79_725 VDD VSS sg13g2_fill_1
XFILLER_78_257 VDD VSS sg13g2_decap_8
XFILLER_19_313 VDD VSS sg13g2_fill_1
Xfanout270 fanout274/X fanout270/X VDD VSS sg13g2_buf_1
Xfanout281 fanout283/X fanout281/X VDD VSS sg13g2_buf_1
Xfanout292 fanout293/X fanout292/X VDD VSS sg13g2_buf_1
XFILLER_19_368 VDD VSS sg13g2_fill_2
XFILLER_35_828 VDD VSS sg13g2_fill_2
XFILLER_46_143 VDD VSS sg13g2_fill_2
XFILLER_46_176 VDD VSS sg13g2_decap_8
XFILLER_90_901 VDD VSS sg13g2_fill_1
XFILLER_28_880 VDD VSS sg13g2_decap_4
XFILLER_43_872 VDD VSS sg13g2_decap_8
XFILLER_61_179 VDD VSS sg13g2_decap_8
XFILLER_30_544 VDD VSS sg13g2_fill_2
XFILLER_30_588 VDD VSS sg13g2_fill_1
XFILLER_30_599 VDD VSS sg13g2_decap_4
XFILLER_11_780 VDD VSS sg13g2_decap_8
X_3520_ _4861_/Q _4863_/Q _3523_/A VDD VSS sg13g2_nor2_1
XFILLER_7_762 VDD VSS sg13g2_decap_8
Xhold718 _4493_/Q VDD VSS _3067_/A sg13g2_dlygate4sd3_1
Xhold707 _4009_/Y VDD VSS _4839_/D sg13g2_dlygate4sd3_1
Xhold729 _4622_/Q VDD VSS hold729/X sg13g2_dlygate4sd3_1
X_3451_ _3453_/B _3453_/C _3451_/A _3451_/Y VDD VSS sg13g2_nand3_1
X_3382_ VSS VDD _3326_/C _3381_/Y _3382_/Y _4791_/Q sg13g2_a21oi_1
X_2402_ _2402_/Y _2402_/B _2819_/A VDD VSS sg13g2_nand2b_1
XFILLER_97_511 VDD VSS sg13g2_fill_1
XFILLER_111_310 VDD VSS sg13g2_decap_8
XFILLER_69_235 VDD VSS sg13g2_decap_8
X_2333_ VDD _2655_/A _2333_/A VSS sg13g2_inv_1
Xhold1407 _4867_/Q VDD VSS _2787_/B sg13g2_dlygate4sd3_1
XFILLER_66_920 VDD VSS sg13g2_decap_4
XFILLER_84_227 VDD VSS sg13g2_fill_2
Xhold1418 _3856_/X VDD VSS _4793_/D sg13g2_dlygate4sd3_1
Xhold1429 _4687_/Q VDD VSS _3513_/A sg13g2_dlygate4sd3_1
X_2264_ VDD _2264_/Y _4652_/Q VSS sg13g2_inv_1
XFILLER_97_588 VDD VSS sg13g2_decap_8
XFILLER_37_121 VDD VSS sg13g2_decap_8
XFILLER_65_430 VDD VSS sg13g2_fill_2
XFILLER_84_238 VDD VSS sg13g2_decap_8
X_4003_ _4003_/A _4003_/B _4838_/D VDD VSS sg13g2_and2_1
XFILLER_93_783 VDD VSS sg13g2_decap_8
XFILLER_111_28 VDD VSS sg13g2_decap_8
XFILLER_1_93 VDD VSS sg13g2_decap_8
XFILLER_111_39 VDD VSS sg13g2_fill_2
XFILLER_34_872 VDD VSS sg13g2_decap_4
XFILLER_80_444 VDD VSS sg13g2_decap_8
XFILLER_21_511 VDD VSS sg13g2_decap_8
XFILLER_33_360 VDD VSS sg13g2_decap_8
X_4905_ fanout259/X VSS VDD _4905_/D _4905_/Q _4907_/CLK sg13g2_dfrbpq_1
X_4836_ fanout269/X VSS VDD _4836_/D _4836_/Q _4841_/CLK sg13g2_dfrbpq_1
XFILLER_21_577 VDD VSS sg13g2_decap_8
X_4767_ fanout249/X VSS VDD _4767_/D _4767_/Q clkload1/A sg13g2_dfrbpq_1
XFILLER_107_627 VDD VSS sg13g2_decap_8
XFILLER_20_14 VDD VSS sg13g2_decap_8
X_4698_ fanout325/X VSS VDD _4698_/D _4698_/Q _4868_/CLK sg13g2_dfrbpq_1
X_3718_ _3719_/C _3718_/A _3718_/B _3718_/C VDD VSS sg13g2_and3_1
X_3649_ _3649_/Y _3649_/A _3652_/S VDD VSS sg13g2_nand2_1
XFILLER_20_69 VDD VSS sg13g2_decap_8
XFILLER_102_321 VDD VSS sg13g2_decap_8
XFILLER_88_544 VDD VSS sg13g2_decap_8
XFILLER_88_511 VDD VSS sg13g2_decap_4
XFILLER_0_459 VDD VSS sg13g2_decap_8
XFILLER_103_855 VDD VSS sg13g2_fill_1
XFILLER_29_67 VDD VSS sg13g2_decap_8
XFILLER_28_110 VDD VSS sg13g2_decap_8
XFILLER_56_441 VDD VSS sg13g2_decap_8
XFILLER_17_839 VDD VSS sg13g2_decap_8
XFILLER_29_666 VDD VSS sg13g2_decap_8
XFILLER_44_603 VDD VSS sg13g2_decap_8
XFILLER_72_901 VDD VSS sg13g2_decap_8
XFILLER_28_176 VDD VSS sg13g2_decap_8
XFILLER_28_198 VDD VSS sg13g2_decap_8
XFILLER_56_496 VDD VSS sg13g2_decap_8
XFILLER_84_794 VDD VSS sg13g2_decap_8
XFILLER_101_61 VDD VSS sg13g2_decap_8
XFILLER_40_864 VDD VSS sg13g2_decap_8
XFILLER_61_21 VDD VSS sg13g2_decap_8
XFILLER_12_566 VDD VSS sg13g2_fill_2
XFILLER_12_577 VDD VSS sg13g2_decap_8
XFILLER_8_515 VDD VSS sg13g2_decap_8
XFILLER_61_98 VDD VSS sg13g2_decap_8
XFILLER_4_732 VDD VSS sg13g2_decap_8
XFILLER_67_717 VDD VSS sg13g2_fill_2
XFILLER_79_555 VDD VSS sg13g2_decap_8
XFILLER_48_920 VDD VSS sg13g2_decap_4
XFILLER_94_514 VDD VSS sg13g2_fill_2
XFILLER_86_73 VDD VSS sg13g2_decap_8
XFILLER_13_7 VDD VSS sg13g2_decap_8
XFILLER_86_95 VDD VSS sg13g2_decap_8
XFILLER_19_165 VDD VSS sg13g2_decap_8
XFILLER_47_474 VDD VSS sg13g2_decap_8
XFILLER_34_102 VDD VSS sg13g2_decap_8
XFILLER_35_636 VDD VSS sg13g2_decap_8
XFILLER_90_742 VDD VSS sg13g2_decap_8
XFILLER_16_850 VDD VSS sg13g2_decap_4
XFILLER_62_444 VDD VSS sg13g2_decap_8
XFILLER_62_455 VDD VSS sg13g2_fill_1
XFILLER_34_168 VDD VSS sg13g2_decap_8
XFILLER_50_639 VDD VSS sg13g2_decap_8
X_2951_ _2951_/A0 _3106_/A0 _2955_/S _4381_/D VDD VSS sg13g2_mux2_1
XFILLER_31_853 VDD VSS sg13g2_decap_8
XFILLER_30_352 VDD VSS sg13g2_decap_8
X_4621_ fanout278/X VSS VDD _4621_/D _4621_/Q _4950_/CLK sg13g2_dfrbpq_1
X_2882_ _4046_/B _3090_/A0 _2902_/S _2882_/X VDD VSS sg13g2_mux2_1
X_4552_ fanout286/X VSS VDD _4552_/D _4552_/Q _4552_/CLK sg13g2_dfrbpq_1
XFILLER_7_570 VDD VSS sg13g2_decap_8
X_4483_ fanout308/X VSS VDD _4483_/D _4483_/Q _4978_/CLK sg13g2_dfrbpq_1
X_3503_ _3503_/A _3513_/B _3503_/Y VDD VSS sg13g2_nor2_1
XFILLER_116_457 VDD VSS sg13g2_decap_4
Xhold548 _4485_/Q VDD VSS _2466_/A sg13g2_dlygate4sd3_1
Xhold559 _4868_/Q VDD VSS _2787_/C sg13g2_dlygate4sd3_1
X_3434_ _3433_/Y VDD _3434_/Y VSS _2268_/Y _3471_/C sg13g2_o21ai_1
XFILLER_112_641 VDD VSS sg13g2_decap_8
X_3365_ _3461_/A _3648_/A1 _3368_/S _4641_/D VDD VSS sg13g2_mux2_1
Xhold1204 _4376_/Q VDD VSS _2946_/A0 sg13g2_dlygate4sd3_1
Xhold1215 _4452_/Q VDD VSS _4174_/A2 sg13g2_dlygate4sd3_1
X_3296_ _2262_/A _3618_/A1 _3368_/S _4625_/D VDD VSS sg13g2_mux2_1
X_2316_ VDD _3396_/A _2316_/A VSS sg13g2_inv_1
XFILLER_97_385 VDD VSS sg13g2_decap_8
XFILLER_100_847 VDD VSS sg13g2_decap_8
Xhold1226 _2974_/X VDD VSS _4403_/D sg13g2_dlygate4sd3_1
Xhold1237 _3190_/Y VDD VSS _4579_/D sg13g2_dlygate4sd3_1
Xhold1248 _4482_/Q VDD VSS _3543_/A1 sg13g2_dlygate4sd3_1
X_2247_ VDD _2483_/A _2247_/A VSS sg13g2_inv_1
XFILLER_85_547 VDD VSS sg13g2_decap_8
Xhold1259 _4302_/Q VDD VSS _4172_/A1 sg13g2_dlygate4sd3_1
XFILLER_25_102 VDD VSS sg13g2_decap_8
XFILLER_25_135 VDD VSS sg13g2_decap_8
XFILLER_25_157 VDD VSS sg13g2_decap_8
XFILLER_26_669 VDD VSS sg13g2_fill_1
XFILLER_53_444 VDD VSS sg13g2_decap_8
XFILLER_53_466 VDD VSS sg13g2_decap_8
XFILLER_34_680 VDD VSS sg13g2_decap_8
XFILLER_40_116 VDD VSS sg13g2_decap_8
XFILLER_80_263 VDD VSS sg13g2_decap_4
XFILLER_22_831 VDD VSS sg13g2_decap_8
XFILLER_31_35 VDD VSS sg13g2_decap_8
X_4819_ fanout313/X VSS VDD _4819_/D _4819_/Q _4824_/CLK sg13g2_dfrbpq_1
XFILLER_107_457 VDD VSS sg13g2_decap_8
Xoutput13 _2718_/B ld2 VDD VSS sg13g2_buf_1
XFILLER_0_245 VDD VSS sg13g2_decap_8
XFILLER_1_768 VDD VSS sg13g2_decap_8
XFILLER_103_663 VDD VSS sg13g2_decap_8
XFILLER_48_216 VDD VSS sg13g2_decap_8
XFILLER_56_21 VDD VSS sg13g2_decap_4
XFILLER_44_411 VDD VSS sg13g2_fill_1
XFILLER_44_422 VDD VSS sg13g2_fill_1
XFILLER_45_923 VDD VSS sg13g2_fill_2
XFILLER_56_98 VDD VSS sg13g2_decap_8
XFILLER_84_580 VDD VSS sg13g2_fill_2
XFILLER_31_105 VDD VSS sg13g2_decap_8
XFILLER_71_252 VDD VSS sg13g2_fill_2
XFILLER_71_274 VDD VSS sg13g2_decap_4
XFILLER_31_149 VDD VSS sg13g2_decap_8
XFILLER_12_352 VDD VSS sg13g2_decap_8
XFILLER_12_363 VDD VSS sg13g2_decap_8
XFILLER_13_875 VDD VSS sg13g2_decap_8
XFILLER_72_97 VDD VSS sg13g2_fill_1
XFILLER_8_301 VDD VSS sg13g2_decap_8
XFILLER_12_374 VDD VSS sg13g2_fill_1
XFILLER_8_378 VDD VSS sg13g2_fill_2
XFILLER_114_906 VDD VSS sg13g2_decap_8
XFILLER_99_628 VDD VSS sg13g2_decap_8
XFILLER_98_105 VDD VSS sg13g2_fill_2
XFILLER_79_374 VDD VSS sg13g2_decap_8
X_3150_ _3152_/B _3189_/B _3150_/Y VDD VSS sg13g2_nor2_1
XFILLER_95_823 VDD VSS sg13g2_fill_1
X_3081_ _4219_/B hold914/X _3084_/S _4505_/D VDD VSS sg13g2_mux2_1
XFILLER_95_845 VDD VSS sg13g2_decap_8
XFILLER_48_794 VDD VSS sg13g2_decap_8
XFILLER_35_466 VDD VSS sg13g2_decap_4
XFILLER_47_293 VDD VSS sg13g2_decap_8
XFILLER_63_764 VDD VSS sg13g2_decap_8
XFILLER_22_116 VDD VSS sg13g2_decap_8
XFILLER_22_149 VDD VSS sg13g2_decap_8
XFILLER_62_296 VDD VSS sg13g2_decap_8
X_3983_ _3987_/A _3983_/B _3983_/Y VDD VSS sg13g2_nor2_1
XFILLER_15_190 VDD VSS sg13g2_decap_8
X_2934_ hold863/X _3089_/A0 _2953_/S _2934_/X VDD VSS sg13g2_mux2_1
XFILLER_87_0 VDD VSS sg13g2_decap_8
XFILLER_30_182 VDD VSS sg13g2_fill_2
X_2865_ _2865_/A0 _3100_/A0 _2873_/S _2865_/X VDD VSS sg13g2_mux2_1
X_4604_ fanout277/X VSS VDD _4604_/D _4604_/Q _4950_/CLK sg13g2_dfrbpq_1
XFILLER_116_221 VDD VSS sg13g2_decap_8
X_4535_ _2849_/C VSS VDD _4535_/D _4535_/Q _4965_/CLK sg13g2_dfrbpq_1
X_2796_ VSS VDD _4906_/Q _2793_/B _2796_/Y _2414_/C sg13g2_a21oi_1
XFILLER_8_890 VDD VSS sg13g2_decap_8
XFILLER_116_298 VDD VSS sg13g2_fill_1
X_4466_ fanout321/X VSS VDD _4466_/D _4466_/Q _4868_/CLK sg13g2_dfrbpq_1
XFILLER_104_449 VDD VSS sg13g2_fill_2
X_4397_ _4397_/RESET_B VSS VDD _4397_/D _4397_/Q _4397_/CLK sg13g2_dfrbpq_1
X_3417_ _4789_/Q _4788_/Q _4790_/Q _3417_/Y VDD VSS sg13g2_nor3_1
XFILLER_112_460 VDD VSS sg13g2_fill_1
X_3348_ _3348_/A _3348_/B _3360_/B VDD VSS sg13g2_and2_1
XFILLER_58_558 VDD VSS sg13g2_decap_8
Xhold1001 _4272_/Q VDD VSS _2835_/A0 sg13g2_dlygate4sd3_1
Xhold1012 _2901_/X VDD VSS _4334_/D sg13g2_dlygate4sd3_1
Xhold1023 _2927_/X VDD VSS _4359_/D sg13g2_dlygate4sd3_1
XFILLER_73_506 VDD VSS sg13g2_decap_8
XFILLER_85_366 VDD VSS sg13g2_decap_8
Xhold1034 _4930_/Q VDD VSS _2236_/A sg13g2_dlygate4sd3_1
Xhold1045 _3102_/X VDD VSS _4526_/D sg13g2_dlygate4sd3_1
Xhold1056 _4298_/Q VDD VSS _2863_/A0 sg13g2_dlygate4sd3_1
Xhold1067 _4450_/Q VDD VSS _3024_/A0 sg13g2_dlygate4sd3_1
X_3279_ _3279_/A _3278_/Y _4617_/D VDD VSS sg13g2_nor2b_1
Xhold1078 _4679_/Q VDD VSS _3481_/A sg13g2_dlygate4sd3_1
Xhold1089 _4845_/Q VDD VSS _2639_/B1 sg13g2_dlygate4sd3_1
XFILLER_26_57 VDD VSS sg13g2_decap_8
XFILLER_14_606 VDD VSS sg13g2_decap_8
XFILLER_53_263 VDD VSS sg13g2_decap_8
XFILLER_41_447 VDD VSS sg13g2_decap_8
XFILLER_22_661 VDD VSS sg13g2_decap_8
XFILLER_10_867 VDD VSS sg13g2_decap_8
XFILLER_21_193 VDD VSS sg13g2_decap_8
XFILLER_6_805 VDD VSS sg13g2_decap_8
XFILLER_107_232 VDD VSS sg13g2_decap_8
XFILLER_108_766 VDD VSS sg13g2_decap_8
XFILLER_1_510 VDD VSS sg13g2_fill_1
XFILLER_111_909 VDD VSS sg13g2_decap_8
XFILLER_3_28 VDD VSS sg13g2_decap_8
Xhold890 _4296_/Q VDD VSS hold890/X sg13g2_dlygate4sd3_1
XFILLER_107_71 VDD VSS sg13g2_decap_8
XFILLER_107_82 VDD VSS sg13g2_fill_2
XFILLER_110_419 VDD VSS sg13g2_decap_8
XFILLER_49_514 VDD VSS sg13g2_fill_2
XFILLER_67_42 VDD VSS sg13g2_decap_8
XFILLER_76_333 VDD VSS sg13g2_decap_8
XFILLER_77_845 VDD VSS sg13g2_decap_8
XFILLER_89_694 VDD VSS sg13g2_decap_4
XFILLER_88_193 VDD VSS sg13g2_decap_8
XFILLER_37_709 VDD VSS sg13g2_decap_8
XFILLER_64_506 VDD VSS sg13g2_decap_8
XFILLER_77_878 VDD VSS sg13g2_decap_8
XFILLER_77_889 VDD VSS sg13g2_fill_2
XFILLER_29_282 VDD VSS sg13g2_decap_8
XFILLER_92_837 VDD VSS sg13g2_fill_2
XFILLER_91_314 VDD VSS sg13g2_decap_8
Xhold1590 _4936_/Q VDD VSS _2771_/A sg13g2_dlygate4sd3_1
XFILLER_44_252 VDD VSS sg13g2_fill_1
XFILLER_83_74 VDD VSS sg13g2_decap_4
XFILLER_72_594 VDD VSS sg13g2_decap_8
XFILLER_13_683 VDD VSS sg13g2_decap_8
XFILLER_80_7 VDD VSS sg13g2_decap_8
XFILLER_12_193 VDD VSS sg13g2_decap_8
X_2650_ _4718_/Q _4727_/Q _2685_/C VDD VSS sg13g2_nor2_1
XFILLER_9_676 VDD VSS sg13g2_fill_2
XFILLER_8_164 VDD VSS sg13g2_decap_8
X_2581_ _2581_/A _2582_/B _2581_/Y VDD VSS sg13g2_nor2_1
XFILLER_5_893 VDD VSS sg13g2_decap_8
X_4320_ _4320_/RESET_B VSS VDD _4320_/D _4320_/Q _4552_/CLK sg13g2_dfrbpq_1
X_4251_ _4385_/Q _4410_/Q _4251_/S _4251_/X VDD VSS sg13g2_mux2_1
XFILLER_99_447 VDD VSS sg13g2_decap_8
XFILLER_67_300 VDD VSS sg13g2_decap_8
X_3202_ _3202_/Y _3202_/A _3202_/B VDD VSS sg13g2_xnor2_1
X_4182_ _4190_/A1 VDD _4182_/Y VSS _4188_/A1 _4353_/Q sg13g2_o21ai_1
XFILLER_27_208 VDD VSS sg13g2_decap_8
XFILLER_68_889 VDD VSS sg13g2_fill_2
X_3133_ _3132_/Y VDD _3133_/Y VSS _4627_/Q _3138_/B sg13g2_o21ai_1
XFILLER_48_580 VDD VSS sg13g2_decap_8
XFILLER_82_325 VDD VSS sg13g2_decap_8
X_3064_ _4066_/B _3064_/A1 _3083_/S _4490_/D VDD VSS sg13g2_mux2_1
XFILLER_36_753 VDD VSS sg13g2_decap_8
XFILLER_36_764 VDD VSS sg13g2_fill_1
XFILLER_82_358 VDD VSS sg13g2_fill_2
XFILLER_24_915 VDD VSS sg13g2_decap_8
XFILLER_35_241 VDD VSS sg13g2_decap_8
XFILLER_35_252 VDD VSS sg13g2_fill_1
XFILLER_23_447 VDD VSS sg13g2_decap_8
XFILLER_50_211 VDD VSS sg13g2_decap_8
XFILLER_51_745 VDD VSS sg13g2_fill_1
XFILLER_63_594 VDD VSS sg13g2_decap_8
X_3966_ _3966_/Y input7/X _4848_/D VDD VSS sg13g2_nand2_1
XFILLER_10_108 VDD VSS sg13g2_decap_8
XFILLER_50_277 VDD VSS sg13g2_decap_8
X_2917_ hold878/X _3023_/A1 _2926_/S _2917_/X VDD VSS sg13g2_mux2_1
XFILLER_109_508 VDD VSS sg13g2_fill_1
X_3897_ VSS VDD _3905_/C _3895_/Y _4808_/D _3897_/B1 sg13g2_a21oi_1
X_2848_ _2848_/A0 _3110_/A0 _2848_/S _2848_/X VDD VSS sg13g2_mux2_1
X_2779_ VSS VDD _4939_/Q _2780_/C _2779_/Y _2780_/B sg13g2_a21oi_1
X_4518_ fanout288/X VSS VDD _4518_/D _4518_/Q _4927_/CLK sg13g2_dfrbpq_1
XFILLER_104_246 VDD VSS sg13g2_decap_8
X_4449_ _4449_/RESET_B VSS VDD _4449_/D _4449_/Q _4968_/CLK sg13g2_dfrbpq_1
XFILLER_101_920 VDD VSS sg13g2_decap_4
XFILLER_100_430 VDD VSS sg13g2_decap_8
XFILLER_59_867 VDD VSS sg13g2_decap_8
XFILLER_100_496 VDD VSS sg13g2_decap_8
XFILLER_37_56 VDD VSS sg13g2_decap_8
XFILLER_73_314 VDD VSS sg13g2_decap_4
XFILLER_27_731 VDD VSS sg13g2_decap_8
XFILLER_85_196 VDD VSS sg13g2_decap_4
XFILLER_15_915 VDD VSS sg13g2_decap_8
XFILLER_14_425 VDD VSS sg13g2_decap_8
XFILLER_42_734 VDD VSS sg13g2_decap_8
XFILLER_5_101 VDD VSS sg13g2_decap_8
XFILLER_6_613 VDD VSS sg13g2_decap_8
XFILLER_108_574 VDD VSS sg13g2_fill_1
XFILLER_5_156 VDD VSS sg13g2_decap_8
XFILLER_2_841 VDD VSS sg13g2_decap_8
XFILLER_69_609 VDD VSS sg13g2_fill_2
XFILLER_110_227 VDD VSS sg13g2_decap_4
XFILLER_1_373 VDD VSS sg13g2_decap_8
XFILLER_110_249 VDD VSS sg13g2_decap_4
XFILLER_76_130 VDD VSS sg13g2_fill_1
XFILLER_92_601 VDD VSS sg13g2_decap_8
XFILLER_65_837 VDD VSS sg13g2_decap_8
XFILLER_76_185 VDD VSS sg13g2_decap_8
XFILLER_92_634 VDD VSS sg13g2_decap_8
XFILLER_18_731 VDD VSS sg13g2_decap_4
XFILLER_18_797 VDD VSS sg13g2_decap_8
XFILLER_64_369 VDD VSS sg13g2_fill_1
XFILLER_73_870 VDD VSS sg13g2_decap_8
XFILLER_33_734 VDD VSS sg13g2_decap_8
XFILLER_45_594 VDD VSS sg13g2_decap_8
XFILLER_91_199 VDD VSS sg13g2_fill_2
X_3820_ _3821_/B _3820_/A _3820_/B VDD VSS sg13g2_xnor2_1
X_3751_ _3764_/D _4763_/Q _3751_/B _3751_/C VDD VSS sg13g2_and3_1
XFILLER_13_480 VDD VSS sg13g2_decap_8
X_2702_ _2702_/B _2702_/C _4729_/Q _2703_/C VDD VSS _3603_/C sg13g2_nand4_1
X_3682_ _4747_/Q _4746_/Q _3717_/B _3698_/D VDD VSS sg13g2_or3_1
XFILLER_9_473 VDD VSS sg13g2_decap_8
X_2633_ _2632_/Y VDD _2633_/Y VSS _3278_/A _4004_/A sg13g2_o21ai_1
X_2564_ _4885_/D _2564_/A _2572_/A VDD VSS sg13g2_xnor2_1
XFILLER_5_690 VDD VSS sg13g2_decap_8
X_4303_ _4303_/RESET_B VSS VDD _4303_/D _4303_/Q _4527_/CLK sg13g2_dfrbpq_1
XFILLER_102_728 VDD VSS sg13g2_decap_8
XFILLER_59_108 VDD VSS sg13g2_fill_2
X_2495_ VSS VDD _2648_/C _4727_/Q _4726_/Q sg13g2_or2_1
XFILLER_99_255 VDD VSS sg13g2_decap_8
X_4234_ _4236_/A1 VDD _4234_/Y VSS _4231_/Y _4232_/Y sg13g2_o21ai_1
XFILLER_99_288 VDD VSS sg13g2_decap_4
XFILLER_68_653 VDD VSS sg13g2_decap_4
X_4165_ _4186_/S _4376_/Q _4165_/Y VDD VSS sg13g2_nor2_1
XFILLER_56_837 VDD VSS sg13g2_decap_8
X_3116_ _4643_/Q _3116_/A1 _3136_/B _3116_/X VDD VSS sg13g2_mux2_1
XFILLER_55_358 VDD VSS sg13g2_decap_8
XFILLER_83_656 VDD VSS sg13g2_decap_8
X_4096_ _4196_/B1 VDD _4096_/Y VSS _4196_/A1 _4344_/Q sg13g2_o21ai_1
XFILLER_36_572 VDD VSS sg13g2_decap_8
XFILLER_64_870 VDD VSS sg13g2_fill_1
XFILLER_82_177 VDD VSS sg13g2_decap_8
X_3047_ _4473_/Q _3074_/A1 _3056_/S _3047_/X VDD VSS sg13g2_mux2_1
XFILLER_23_222 VDD VSS sg13g2_fill_1
XFILLER_70_339 VDD VSS sg13g2_decap_8
XFILLER_24_767 VDD VSS sg13g2_fill_1
XFILLER_51_553 VDD VSS sg13g2_decap_8
XFILLER_11_417 VDD VSS sg13g2_decap_8
XFILLER_23_288 VDD VSS sg13g2_decap_8
X_3949_ _3948_/Y VDD _3949_/Y VSS _3954_/B _3947_/A sg13g2_o21ai_1
XFILLER_109_338 VDD VSS sg13g2_decap_8
XFILLER_3_616 VDD VSS sg13g2_decap_4
XFILLER_48_11 VDD VSS sg13g2_fill_1
XFILLER_59_631 VDD VSS sg13g2_decap_4
XFILLER_101_750 VDD VSS sg13g2_decap_8
XFILLER_48_66 VDD VSS sg13g2_decap_8
XFILLER_100_260 VDD VSS sg13g2_decap_4
XFILLER_58_185 VDD VSS sg13g2_decap_8
XFILLER_62_807 VDD VSS sg13g2_decap_8
XFILLER_64_21 VDD VSS sg13g2_decap_8
XFILLER_73_133 VDD VSS sg13g2_decap_8
XFILLER_74_667 VDD VSS sg13g2_decap_8
XFILLER_14_200 VDD VSS sg13g2_fill_1
XFILLER_15_767 VDD VSS sg13g2_decap_8
XFILLER_42_542 VDD VSS sg13g2_fill_1
XFILLER_70_862 VDD VSS sg13g2_decap_4
XFILLER_30_737 VDD VSS sg13g2_decap_8
XFILLER_42_575 VDD VSS sg13g2_fill_1
XFILLER_80_42 VDD VSS sg13g2_decap_8
XFILLER_14_299 VDD VSS sg13g2_decap_8
XFILLER_7_900 VDD VSS sg13g2_decap_8
Xfanout70 _2722_/A _3972_/D VDD VSS sg13g2_buf_1
Xfanout81 _3002_/S _3007_/S VDD VSS sg13g2_buf_1
Xfanout92 fanout93/X _2949_/S VDD VSS sg13g2_buf_1
XFILLER_13_80 VDD VSS sg13g2_fill_2
XFILLER_6_432 VDD VSS sg13g2_decap_8
XFILLER_108_382 VDD VSS sg13g2_decap_8
XFILLER_89_84 VDD VSS sg13g2_fill_1
XFILLER_89_73 VDD VSS sg13g2_fill_2
XFILLER_43_7 VDD VSS sg13g2_decap_8
XFILLER_69_439 VDD VSS sg13g2_fill_2
X_2280_ VDD _2280_/Y _4668_/Q VSS sg13g2_inv_1
XFILLER_49_130 VDD VSS sg13g2_decap_8
XFILLER_96_269 VDD VSS sg13g2_decap_4
XFILLER_77_461 VDD VSS sg13g2_decap_8
XFILLER_37_325 VDD VSS sg13g2_fill_1
XFILLER_49_185 VDD VSS sg13g2_decap_8
XFILLER_64_122 VDD VSS sg13g2_decap_8
XFILLER_52_317 VDD VSS sg13g2_fill_1
XFILLER_64_166 VDD VSS sg13g2_decap_8
XFILLER_65_689 VDD VSS sg13g2_decap_8
XFILLER_18_594 VDD VSS sg13g2_decap_8
X_4921_ fanout262/X VSS VDD _4921_/D _4921_/Q clkload5/A sg13g2_dfrbpq_1
X_4852_ fanout315/X VSS VDD _4852_/D _4852_/Q _4929_/CLK sg13g2_dfrbpq_1
X_3803_ VSS VDD _3851_/B _3847_/B _4771_/Q sg13g2_or2_1
X_4783_ fanout250/X VSS VDD _4783_/D _4783_/Q clkload0/A sg13g2_dfrbpq_1
X_3734_ _3734_/B1 VDD _4758_/D VSS _3766_/A1 _3809_/A sg13g2_o21ai_1
XFILLER_9_270 VDD VSS sg13g2_fill_1
XFILLER_109_28 VDD VSS sg13g2_decap_8
X_3665_ _4736_/Q _4735_/Q _3708_/B VDD VSS sg13g2_nor2_1
Xclkload40 clkload40/Y _4941_/CLK VDD VSS sg13g2_inv_2
X_2616_ _3275_/A _2616_/B _3275_/B _3280_/B VDD VSS sg13g2_or3_1
XFILLER_114_330 VDD VSS sg13g2_decap_4
XFILLER_115_842 VDD VSS sg13g2_decap_8
X_3596_ _3596_/B _3596_/C _3596_/A _3598_/B VDD VSS sg13g2_nand3_1
X_2547_ _2547_/Y _2547_/A _2547_/B VDD VSS sg13g2_xnor2_1
XFILLER_88_704 VDD VSS sg13g2_decap_8
X_2478_ _3901_/D _4808_/Q _4809_/Q VDD VSS sg13g2_nand2_1
X_4217_ VSS VDD _4225_/A1 _4215_/X _4217_/Y _4216_/Y sg13g2_a21oi_1
XFILLER_18_14 VDD VSS sg13g2_decap_8
XFILLER_28_314 VDD VSS sg13g2_decap_4
XFILLER_29_826 VDD VSS sg13g2_decap_8
X_4148_ _4148_/Y _4148_/B _4147_/B1 VDD VSS sg13g2_nand2b_1
XFILLER_28_358 VDD VSS sg13g2_fill_1
XFILLER_44_818 VDD VSS sg13g2_decap_8
XFILLER_55_166 VDD VSS sg13g2_decap_4
XFILLER_56_678 VDD VSS sg13g2_decap_8
X_4079_ _4079_/Y _4079_/B _4078_/A VDD VSS sg13g2_nand2b_1
XFILLER_24_520 VDD VSS sg13g2_decap_8
XFILLER_55_199 VDD VSS sg13g2_decap_8
XFILLER_70_114 VDD VSS sg13g2_decap_8
XFILLER_83_486 VDD VSS sg13g2_fill_2
XFILLER_83_497 VDD VSS sg13g2_decap_8
XFILLER_11_214 VDD VSS sg13g2_decap_8
XFILLER_8_708 VDD VSS sg13g2_decap_8
XFILLER_109_113 VDD VSS sg13g2_decap_8
Xclkload1 clkload1/Y clkload1/A VDD VSS sg13g2_inv_2
XFILLER_50_56 VDD VSS sg13g2_decap_8
XFILLER_4_914 VDD VSS sg13g2_decap_8
XFILLER_4_925 VDD VSS sg13g2_fill_1
XFILLER_50_89 VDD VSS sg13g2_decap_8
XFILLER_106_853 VDD VSS sg13g2_decap_8
XFILLER_3_424 VDD VSS sg13g2_decap_8
XFILLER_3_435 VDD VSS sg13g2_fill_1
XFILLER_105_330 VDD VSS sg13g2_fill_2
XFILLER_59_21 VDD VSS sg13g2_decap_8
XFILLER_105_374 VDD VSS sg13g2_decap_8
XFILLER_78_236 VDD VSS sg13g2_decap_8
XFILLER_47_601 VDD VSS sg13g2_decap_8
Xfanout260 fanout262/X fanout260/X VDD VSS sg13g2_buf_1
Xfanout271 fanout274/X fanout271/X VDD VSS sg13g2_buf_1
Xfanout282 fanout283/X fanout282/X VDD VSS sg13g2_buf_1
XFILLER_93_206 VDD VSS sg13g2_decap_4
XFILLER_19_347 VDD VSS sg13g2_decap_8
XFILLER_46_122 VDD VSS sg13g2_decap_8
Xfanout293 fanout294/X fanout293/X VDD VSS sg13g2_buf_1
XFILLER_62_604 VDD VSS sg13g2_decap_8
XFILLER_62_648 VDD VSS sg13g2_decap_8
XFILLER_62_659 VDD VSS sg13g2_fill_1
XFILLER_74_497 VDD VSS sg13g2_decap_8
XFILLER_43_851 VDD VSS sg13g2_decap_8
XFILLER_61_158 VDD VSS sg13g2_decap_8
XFILLER_15_564 VDD VSS sg13g2_decap_8
XFILLER_42_350 VDD VSS sg13g2_decap_4
XFILLER_70_681 VDD VSS sg13g2_decap_8
XFILLER_91_63 VDD VSS sg13g2_decap_8
XFILLER_30_523 VDD VSS sg13g2_decap_8
XFILLER_10_280 VDD VSS sg13g2_decap_8
XFILLER_7_741 VDD VSS sg13g2_decap_8
XFILLER_116_617 VDD VSS sg13g2_decap_4
XFILLER_6_240 VDD VSS sg13g2_fill_2
Xhold719 _4891_/Q VDD VSS _2583_/A sg13g2_dlygate4sd3_1
Xhold708 _4869_/Q VDD VSS _2714_/B sg13g2_dlygate4sd3_1
XFILLER_6_284 VDD VSS sg13g2_decap_8
X_3450_ _3449_/Y VDD _3450_/Y VSS _2267_/Y _3453_/C sg13g2_o21ai_1
X_3381_ _3413_/C _3381_/C _4788_/Q _3381_/Y VDD VSS sg13g2_nand3_1
X_2401_ _2399_/Y _2412_/C _2400_/X _2401_/X VDD VSS sg13g2_a21o_1
XFILLER_97_501 VDD VSS sg13g2_fill_1
XFILLER_69_214 VDD VSS sg13g2_fill_1
X_2332_ VDD _3514_/A _3513_/A VSS sg13g2_inv_1
XFILLER_111_333 VDD VSS sg13g2_fill_1
XFILLER_97_567 VDD VSS sg13g2_decap_8
XFILLER_78_781 VDD VSS sg13g2_decap_8
Xhold1408 _4597_/Q VDD VSS _3229_/A sg13g2_dlygate4sd3_1
Xhold1419 _4734_/Q VDD VSS _3622_/A0 sg13g2_dlygate4sd3_1
X_4002_ _4001_/Y VDD _4002_/Y VSS _4003_/B _4000_/Y sg13g2_o21ai_1
X_2263_ VDD _2263_/Y _4660_/Q VSS sg13g2_inv_1
XFILLER_37_100 VDD VSS sg13g2_fill_2
XFILLER_37_111 VDD VSS sg13g2_fill_1
XFILLER_38_645 VDD VSS sg13g2_fill_1
XFILLER_38_656 VDD VSS sg13g2_decap_4
XFILLER_77_291 VDD VSS sg13g2_fill_2
XFILLER_1_72 VDD VSS sg13g2_decap_8
XFILLER_65_453 VDD VSS sg13g2_fill_1
XFILLER_65_464 VDD VSS sg13g2_fill_2
XFILLER_81_913 VDD VSS sg13g2_decap_8
XFILLER_81_924 VDD VSS sg13g2_fill_2
XFILLER_93_762 VDD VSS sg13g2_decap_8
XFILLER_52_103 VDD VSS sg13g2_decap_8
XFILLER_80_423 VDD VSS sg13g2_decap_8
XFILLER_18_391 VDD VSS sg13g2_decap_8
XFILLER_34_851 VDD VSS sg13g2_decap_8
XFILLER_52_158 VDD VSS sg13g2_decap_4
X_4904_ fanout246/X VSS VDD _4904_/D _4904_/Q _4904_/CLK sg13g2_dfrbpq_1
XFILLER_21_556 VDD VSS sg13g2_decap_8
X_4835_ fanout270/X VSS VDD _4835_/D _4835_/Q _4841_/CLK sg13g2_dfrbpq_1
X_4766_ fanout249/X VSS VDD _4766_/D _4766_/Q clkload1/A sg13g2_dfrbpq_1
X_4399__527 VDD VSS _4399_/RESET_B sg13g2_tiehi
X_3717_ _3718_/C _3717_/A _3717_/B VDD VSS sg13g2_nand2_1
XFILLER_107_606 VDD VSS sg13g2_decap_8
X_4697_ fanout302/X VSS VDD _4697_/D _4697_/Q _4884_/CLK sg13g2_dfrbpq_1
X_3648_ _3648_/A0 _3648_/A1 _3652_/S _4744_/D VDD VSS sg13g2_mux2_1
X_3579_ _3584_/B _3580_/A _3580_/B VDD VSS sg13g2_nand2_1
XFILLER_0_438 VDD VSS sg13g2_decap_8
XFILLER_76_718 VDD VSS sg13g2_decap_8
XFILLER_102_377 VDD VSS sg13g2_decap_8
XFILLER_29_46 VDD VSS sg13g2_decap_8
XFILLER_28_100 VDD VSS sg13g2_decap_4
XFILLER_29_645 VDD VSS sg13g2_decap_8
XFILLER_68_280 VDD VSS sg13g2_decap_8
XFILLER_56_475 VDD VSS sg13g2_decap_8
XFILLER_84_773 VDD VSS sg13g2_decap_8
XFILLER_43_125 VDD VSS sg13g2_decap_4
XFILLER_44_659 VDD VSS sg13g2_decap_8
XFILLER_45_67 VDD VSS sg13g2_decap_8
XFILLER_45_78 VDD VSS sg13g2_fill_1
XFILLER_101_40 VDD VSS sg13g2_decap_8
XFILLER_40_832 VDD VSS sg13g2_fill_1
XFILLER_61_77 VDD VSS sg13g2_decap_8
XFILLER_8_505 VDD VSS sg13g2_fill_1
XFILLER_4_711 VDD VSS sg13g2_decap_8
XFILLER_10_70 VDD VSS sg13g2_decap_8
XFILLER_112_119 VDD VSS sg13g2_fill_1
XFILLER_4_788 VDD VSS sg13g2_decap_8
XFILLER_79_534 VDD VSS sg13g2_decap_8
XFILLER_66_239 VDD VSS sg13g2_decap_8
XFILLER_75_740 VDD VSS sg13g2_decap_4
XFILLER_19_144 VDD VSS sg13g2_decap_8
XFILLER_47_453 VDD VSS sg13g2_decap_8
XFILLER_19_188 VDD VSS sg13g2_fill_1
XFILLER_35_615 VDD VSS sg13g2_decap_8
XFILLER_62_423 VDD VSS sg13g2_decap_8
XFILLER_34_147 VDD VSS sg13g2_decap_8
X_2950_ hold856/X _3105_/A0 _2953_/S _4380_/D VDD VSS sg13g2_mux2_1
XFILLER_90_798 VDD VSS sg13g2_fill_2
XFILLER_15_383 VDD VSS sg13g2_fill_1
XFILLER_15_394 VDD VSS sg13g2_decap_8
XFILLER_30_331 VDD VSS sg13g2_decap_8
XFILLER_31_832 VDD VSS sg13g2_decap_8
X_2881_ hold942/X _3089_/A0 _2900_/S _2881_/X VDD VSS sg13g2_mux2_1
X_4620_ fanout278/X VSS VDD _4620_/D _4620_/Q _4950_/CLK sg13g2_dfrbpq_1
X_4551_ fanout267/X VSS VDD _4551_/D _4551_/Q clkload9/A sg13g2_dfrbpq_1
XFILLER_116_436 VDD VSS sg13g2_decap_8
X_4482_ fanout302/X VSS VDD _4482_/D _4482_/Q _4974_/CLK sg13g2_dfrbpq_1
X_3502_ _3504_/C VDD _3513_/B VSS _3506_/A _3504_/B sg13g2_o21ai_1
Xhold538 _4853_/Q VDD VSS _4929_/D sg13g2_dlygate4sd3_1
Xhold549 _4926_/Q VDD VSS _2819_/A sg13g2_dlygate4sd3_1
X_3433_ _3453_/B _3471_/C _3433_/A _3433_/Y VDD VSS sg13g2_nand3_1
XFILLER_103_119 VDD VSS sg13g2_decap_8
XFILLER_98_843 VDD VSS sg13g2_fill_1
XFILLER_32_0 VDD VSS sg13g2_decap_8
X_3364_ _3459_/A _3646_/A _3368_/S _4640_/D VDD VSS sg13g2_mux2_1
XFILLER_100_826 VDD VSS sg13g2_decap_8
XFILLER_111_163 VDD VSS sg13g2_decap_8
XFILLER_112_675 VDD VSS sg13g2_decap_8
XFILLER_58_729 VDD VSS sg13g2_decap_8
Xhold1205 _4543_/Q VDD VSS _3119_/A1 sg13g2_dlygate4sd3_1
Xhold1216 _3026_/X VDD VSS _4452_/D sg13g2_dlygate4sd3_1
X_3295_ _3528_/A _3295_/B _4624_/D VDD VSS sg13g2_and2_1
X_2315_ VDD _3337_/A _2315_/A VSS sg13g2_inv_1
XFILLER_97_364 VDD VSS sg13g2_decap_8
XFILLER_57_228 VDD VSS sg13g2_decap_8
Xhold1227 _4947_/Q VDD VSS _2733_/A sg13g2_dlygate4sd3_1
Xhold1238 _4459_/Q VDD VSS _3033_/A0 sg13g2_dlygate4sd3_1
Xhold1249 _4957_/Q VDD VSS _4035_/B sg13g2_dlygate4sd3_1
X_2246_ VDD _3901_/B _3902_/C VSS sg13g2_inv_1
XFILLER_65_250 VDD VSS sg13g2_fill_2
XFILLER_53_423 VDD VSS sg13g2_decap_8
XFILLER_54_924 VDD VSS sg13g2_fill_2
XFILLER_65_294 VDD VSS sg13g2_fill_2
XFILLER_15_48 VDD VSS sg13g2_fill_2
XFILLER_34_670 VDD VSS sg13g2_fill_1
XFILLER_40_106 VDD VSS sg13g2_fill_1
XFILLER_80_253 VDD VSS sg13g2_fill_1
XFILLER_15_59 VDD VSS sg13g2_decap_8
XFILLER_33_191 VDD VSS sg13g2_decap_8
XFILLER_31_14 VDD VSS sg13g2_decap_8
X_4818_ fanout313/X VSS VDD _4818_/D _4818_/Q _4824_/CLK sg13g2_dfrbpq_1
XFILLER_31_58 VDD VSS sg13g2_decap_8
X_4749_ fanout287/X VSS VDD _4749_/D _4749_/Q _4749_/CLK sg13g2_dfrbpq_1
XFILLER_107_414 VDD VSS sg13g2_fill_2
XFILLER_110_7 VDD VSS sg13g2_decap_8
Xoutput14 _2517_/Y ld3 VDD VSS sg13g2_buf_1
XFILLER_0_224 VDD VSS sg13g2_decap_8
XFILLER_103_642 VDD VSS sg13g2_decap_8
XFILLER_1_747 VDD VSS sg13g2_decap_8
XFILLER_88_364 VDD VSS sg13g2_fill_2
XFILLER_102_185 VDD VSS sg13g2_fill_2
XFILLER_103_697 VDD VSS sg13g2_decap_8
XFILLER_29_420 VDD VSS sg13g2_decap_8
XFILLER_17_604 VDD VSS sg13g2_decap_8
XFILLER_56_77 VDD VSS sg13g2_decap_8
XFILLER_56_294 VDD VSS sg13g2_decap_8
XFILLER_71_242 VDD VSS sg13g2_decap_4
XFILLER_13_810 VDD VSS sg13g2_decap_8
XFILLER_25_670 VDD VSS sg13g2_fill_1
XFILLER_72_21 VDD VSS sg13g2_fill_2
XFILLER_72_787 VDD VSS sg13g2_decap_8
XFILLER_24_180 VDD VSS sg13g2_decap_8
XFILLER_31_128 VDD VSS sg13g2_decap_8
XFILLER_72_65 VDD VSS sg13g2_decap_4
XFILLER_8_357 VDD VSS sg13g2_decap_8
XFILLER_99_607 VDD VSS sg13g2_decap_8
XFILLER_113_439 VDD VSS sg13g2_fill_2
XFILLER_106_491 VDD VSS sg13g2_decap_8
XFILLER_97_73 VDD VSS sg13g2_decap_8
XFILLER_67_504 VDD VSS sg13g2_decap_8
X_3080_ _4210_/B hold993/X _3083_/S _4504_/D VDD VSS sg13g2_mux2_1
XFILLER_48_773 VDD VSS sg13g2_decap_8
XFILLER_35_401 VDD VSS sg13g2_decap_8
XFILLER_47_272 VDD VSS sg13g2_decap_8
XFILLER_75_570 VDD VSS sg13g2_decap_8
XFILLER_75_592 VDD VSS sg13g2_decap_8
X_4389__537 VDD VSS _4389_/RESET_B sg13g2_tiehi
XFILLER_35_445 VDD VSS sg13g2_decap_8
XFILLER_63_743 VDD VSS sg13g2_decap_8
XFILLER_90_551 VDD VSS sg13g2_decap_8
XFILLER_23_607 VDD VSS sg13g2_decap_8
XFILLER_23_618 VDD VSS sg13g2_fill_2
XFILLER_62_275 VDD VSS sg13g2_decap_8
X_3982_ _3981_/Y VDD _3982_/Y VSS _3985_/B _3980_/Y sg13g2_o21ai_1
XFILLER_90_584 VDD VSS sg13g2_decap_8
XFILLER_50_426 VDD VSS sg13g2_decap_8
X_2933_ hold834/X _3088_/A0 _2953_/S _2933_/X VDD VSS sg13g2_mux2_1
XFILLER_31_640 VDD VSS sg13g2_decap_4
XFILLER_30_161 VDD VSS sg13g2_decap_8
XFILLER_31_684 VDD VSS sg13g2_decap_8
X_2864_ _2864_/A0 _3023_/A1 _2873_/S _2864_/X VDD VSS sg13g2_mux2_1
X_4603_ fanout277/X VSS VDD _4603_/D _4603_/Q _4950_/CLK sg13g2_dfrbpq_1
X_2795_ VSS VDD _2414_/B _2793_/B _2795_/Y _2794_/Y sg13g2_a21oi_1
XFILLER_116_200 VDD VSS sg13g2_decap_8
XFILLER_7_82 VDD VSS sg13g2_decap_8
X_4534_ fanout312/X VSS VDD _4534_/D _4534_/Q _4959_/CLK sg13g2_dfrbpq_1
XFILLER_104_428 VDD VSS sg13g2_decap_8
XFILLER_116_277 VDD VSS sg13g2_decap_8
X_4465_ fanout307/X VSS VDD _4465_/D _4465_/Q _4978_/CLK sg13g2_dfrbpq_1
XFILLER_89_128 VDD VSS sg13g2_fill_1
X_4396_ _4396_/RESET_B VSS VDD _4396_/D _4396_/Q _4965_/CLK sg13g2_dfrbpq_1
X_3416_ _3416_/A _3416_/B _3416_/C _3416_/Y VDD VSS sg13g2_nor3_1
X_3347_ VSS VDD _3348_/A _3469_/C _3350_/B _3348_/B sg13g2_a21oi_1
XFILLER_86_824 VDD VSS sg13g2_fill_2
XFILLER_100_645 VDD VSS sg13g2_decap_4
XFILLER_112_483 VDD VSS sg13g2_decap_8
XFILLER_58_537 VDD VSS sg13g2_fill_2
Xhold1002 _2835_/X VDD VSS _4272_/D sg13g2_dlygate4sd3_1
Xhold1013 _4390_/Q VDD VSS _4053_/A2 sg13g2_dlygate4sd3_1
Xhold1024 _4475_/Q VDD VSS _3536_/A1 sg13g2_dlygate4sd3_1
Xhold1035 _4354_/Q VDD VSS _2922_/A0 sg13g2_dlygate4sd3_1
Xhold1046 _4348_/Q VDD VSS _2916_/A0 sg13g2_dlygate4sd3_1
Xhold1057 _4271_/Q VDD VSS _2834_/A0 sg13g2_dlygate4sd3_1
X_3278_ _3280_/B _3278_/C _3278_/A _3278_/Y VDD VSS sg13g2_nand3_1
XFILLER_26_14 VDD VSS sg13g2_decap_4
Xhold1068 _3024_/X VDD VSS _4450_/D sg13g2_dlygate4sd3_1
Xhold1079 _4398_/Q VDD VSS _2969_/A0 sg13g2_dlygate4sd3_1
XFILLER_26_36 VDD VSS sg13g2_decap_8
XFILLER_42_905 VDD VSS sg13g2_fill_2
XFILLER_26_478 VDD VSS sg13g2_fill_1
XFILLER_54_798 VDD VSS sg13g2_decap_8
XFILLER_41_426 VDD VSS sg13g2_decap_8
XFILLER_22_640 VDD VSS sg13g2_decap_8
XFILLER_108_701 VDD VSS sg13g2_decap_8
XFILLER_10_846 VDD VSS sg13g2_decap_8
XFILLER_42_79 VDD VSS sg13g2_decap_8
XFILLER_107_211 VDD VSS sg13g2_decap_8
XFILLER_108_745 VDD VSS sg13g2_decap_8
XFILLER_5_349 VDD VSS sg13g2_decap_8
Xhold891 _2861_/X VDD VSS _4296_/D sg13g2_dlygate4sd3_1
Xhold880 _4416_/Q VDD VSS hold880/X sg13g2_dlygate4sd3_1
XFILLER_103_450 VDD VSS sg13g2_decap_8
XFILLER_67_21 VDD VSS sg13g2_decap_8
XFILLER_77_824 VDD VSS sg13g2_decap_4
XFILLER_89_673 VDD VSS sg13g2_decap_8
XFILLER_103_483 VDD VSS sg13g2_decap_8
XFILLER_76_312 VDD VSS sg13g2_decap_8
XFILLER_67_98 VDD VSS sg13g2_decap_8
XFILLER_17_412 VDD VSS sg13g2_decap_8
XFILLER_18_924 VDD VSS sg13g2_fill_2
XFILLER_29_261 VDD VSS sg13g2_decap_8
Xhold1580 _3776_/Y VDD VSS _4770_/D sg13g2_dlygate4sd3_1
XFILLER_57_592 VDD VSS sg13g2_decap_8
XFILLER_83_53 VDD VSS sg13g2_decap_8
Xhold1591 _4918_/Q VDD VSS _2410_/A sg13g2_dlygate4sd3_1
XFILLER_32_404 VDD VSS sg13g2_decap_8
XFILLER_33_916 VDD VSS sg13g2_decap_8
XFILLER_45_765 VDD VSS sg13g2_decap_4
XFILLER_32_448 VDD VSS sg13g2_decap_8
XFILLER_13_662 VDD VSS sg13g2_decap_8
XFILLER_73_7 VDD VSS sg13g2_decap_8
X_2580_ _2582_/B _2583_/A _2583_/B _2583_/D VDD VSS sg13g2_and3_1
XFILLER_5_872 VDD VSS sg13g2_decap_8
X_4250_ _4250_/B1 VDD _4250_/Y VSS _4250_/A1 _4460_/Q sg13g2_o21ai_1
XFILLER_113_269 VDD VSS sg13g2_fill_1
X_4181_ _4186_/S _4328_/Q _4181_/Y VDD VSS sg13g2_nor2_1
X_3201_ _2645_/A VDD _4584_/D VSS _3193_/B _3201_/A2 sg13g2_o21ai_1
XFILLER_86_109 VDD VSS sg13g2_decap_8
XFILLER_68_846 VDD VSS sg13g2_fill_2
XFILLER_68_857 VDD VSS sg13g2_decap_4
X_3132_ _3132_/Y _3132_/A _3138_/B VDD VSS sg13g2_nand2_1
XFILLER_95_643 VDD VSS sg13g2_decap_8
XFILLER_94_131 VDD VSS sg13g2_decap_8
XFILLER_55_518 VDD VSS sg13g2_decap_8
XFILLER_55_529 VDD VSS sg13g2_fill_2
XFILLER_67_389 VDD VSS sg13g2_decap_8
XFILLER_82_304 VDD VSS sg13g2_decap_8
X_3063_ _4959_/Q _3063_/A1 _3085_/S _3063_/X VDD VSS sg13g2_mux2_1
XFILLER_36_732 VDD VSS sg13g2_decap_8
XFILLER_82_348 VDD VSS sg13g2_fill_1
XFILLER_63_551 VDD VSS sg13g2_decap_8
XFILLER_91_871 VDD VSS sg13g2_decap_8
XFILLER_23_415 VDD VSS sg13g2_decap_8
XFILLER_51_724 VDD VSS sg13g2_decap_8
XFILLER_50_256 VDD VSS sg13g2_decap_8
XFILLER_51_779 VDD VSS sg13g2_decap_8
X_3965_ _3964_/Y VDD _4826_/D VSS _4199_/A1 _4848_/D sg13g2_o21ai_1
X_3896_ VSS VDD _3905_/C _3905_/D _3896_/Y _3905_/A sg13g2_a21oi_1
X_2916_ _2916_/A0 _3098_/A0 _2927_/S _4348_/D VDD VSS sg13g2_mux2_1
X_2847_ hold944/X _3109_/A0 _2847_/S _2847_/X VDD VSS sg13g2_mux2_1
XFILLER_12_49 VDD VSS sg13g2_decap_4
X_2778_ _3528_/A _2778_/B _4939_/D VDD VSS sg13g2_and2_1
XFILLER_104_203 VDD VSS sg13g2_fill_2
X_4517_ fanout261/X VSS VDD _4517_/D _4517_/Q clkload6/A sg13g2_dfrbpq_1
XFILLER_104_214 VDD VSS sg13g2_fill_2
XFILLER_105_759 VDD VSS sg13g2_decap_8
X_4448_ _4448_/RESET_B VSS VDD _4448_/D _4448_/Q _4967_/CLK sg13g2_dfrbpq_1
X_4379_ _4379_/RESET_B VSS VDD _4379_/D _4379_/Q _4552_/CLK sg13g2_dfrbpq_1
XFILLER_74_805 VDD VSS sg13g2_fill_2
XFILLER_85_131 VDD VSS sg13g2_fill_1
XFILLER_86_654 VDD VSS sg13g2_fill_1
XFILLER_37_35 VDD VSS sg13g2_decap_8
XFILLER_85_175 VDD VSS sg13g2_fill_2
XFILLER_42_713 VDD VSS sg13g2_decap_8
XFILLER_54_573 VDD VSS sg13g2_fill_2
XFILLER_82_871 VDD VSS sg13g2_decap_8
XFILLER_26_275 VDD VSS sg13g2_decap_8
XFILLER_54_584 VDD VSS sg13g2_fill_2
XFILLER_41_256 VDD VSS sg13g2_decap_8
XFILLER_108_553 VDD VSS sg13g2_decap_8
XFILLER_6_669 VDD VSS sg13g2_decap_8
XFILLER_2_820 VDD VSS sg13g2_decap_8
XFILLER_110_206 VDD VSS sg13g2_decap_8
XFILLER_1_352 VDD VSS sg13g2_decap_8
XFILLER_68_109 VDD VSS sg13g2_decap_8
XFILLER_104_781 VDD VSS sg13g2_decap_4
XFILLER_2_897 VDD VSS sg13g2_decap_8
XFILLER_49_301 VDD VSS sg13g2_decap_8
XFILLER_65_816 VDD VSS sg13g2_decap_8
XFILLER_77_665 VDD VSS sg13g2_decap_4
XFILLER_49_378 VDD VSS sg13g2_decap_8
XFILLER_76_164 VDD VSS sg13g2_decap_8
XFILLER_77_687 VDD VSS sg13g2_decap_8
XFILLER_18_721 VDD VSS sg13g2_fill_1
XFILLER_91_134 VDD VSS sg13g2_fill_2
XFILLER_91_123 VDD VSS sg13g2_decap_8
XFILLER_91_178 VDD VSS sg13g2_decap_8
XFILLER_33_746 VDD VSS sg13g2_fill_1
XFILLER_32_245 VDD VSS sg13g2_decap_8
XFILLER_60_554 VDD VSS sg13g2_fill_2
X_3750_ _3748_/Y VDD _3750_/Y VSS _3753_/A _3749_/Y sg13g2_o21ai_1
X_2701_ _4724_/Q _2701_/B _3603_/C VDD VSS sg13g2_and2_1
X_3681_ _3668_/Y VDD _3681_/Y VSS _3706_/A _3680_/Y sg13g2_o21ai_1
X_2632_ _2632_/Y _2721_/B _3972_/D VDD VSS sg13g2_nand2b_1
X_2563_ _2563_/A _2563_/B _2563_/Y VDD VSS sg13g2_nor2_1
X_4302_ _4302_/RESET_B VSS VDD _4302_/D _4302_/Q _4958_/CLK sg13g2_dfrbpq_1
XFILLER_88_908 VDD VSS sg13g2_decap_8
XFILLER_102_707 VDD VSS sg13g2_decap_8
XFILLER_4_190 VDD VSS sg13g2_decap_8
X_4233_ _4383_/Q _4408_/Q _4233_/S _4233_/X VDD VSS sg13g2_mux2_1
X_2494_ _4726_/Q _4727_/Q _2702_/B VDD VSS sg13g2_nor2_1
XFILLER_110_740 VDD VSS sg13g2_decap_8
XFILLER_114_18 VDD VSS sg13g2_decap_8
XFILLER_56_805 VDD VSS sg13g2_fill_2
X_4164_ _4426_/Q _4451_/Q _4251_/S _4164_/X VDD VSS sg13g2_mux2_1
XFILLER_56_816 VDD VSS sg13g2_decap_8
X_4095_ _4197_/S _4319_/Q _4095_/Y VDD VSS sg13g2_nor2_1
X_3115_ _3649_/A _3115_/A1 _3128_/B _4539_/D VDD VSS sg13g2_mux2_1
XFILLER_95_473 VDD VSS sg13g2_decap_8
XFILLER_55_337 VDD VSS sg13g2_decap_8
XFILLER_83_635 VDD VSS sg13g2_decap_8
X_3046_ _4472_/Q hold854/X _3057_/S _3046_/X VDD VSS sg13g2_mux2_1
XFILLER_70_318 VDD VSS sg13g2_decap_8
XFILLER_23_201 VDD VSS sg13g2_decap_8
XFILLER_51_532 VDD VSS sg13g2_decap_8
XFILLER_24_779 VDD VSS sg13g2_fill_1
XFILLER_23_37 VDD VSS sg13g2_fill_1
X_3948_ _3954_/B _3948_/C _3948_/Y VDD VSS _3944_/Y sg13g2_nand3b_1
XFILLER_109_317 VDD VSS sg13g2_decap_8
X_3879_ _4801_/Q _4802_/Q _4800_/Q _3879_/Y VDD VSS _3879_/D sg13g2_nand4_1
XFILLER_3_7 VDD VSS sg13g2_decap_8
XFILLER_105_567 VDD VSS sg13g2_decap_8
XFILLER_86_473 VDD VSS sg13g2_decap_8
XFILLER_101_795 VDD VSS sg13g2_decap_8
XFILLER_46_326 VDD VSS sg13g2_decap_8
XFILLER_74_646 VDD VSS sg13g2_decap_8
XFILLER_27_551 VDD VSS sg13g2_decap_8
XFILLER_15_713 VDD VSS sg13g2_decap_4
XFILLER_55_882 VDD VSS sg13g2_decap_8
XFILLER_61_329 VDD VSS sg13g2_decap_8
XFILLER_14_234 VDD VSS sg13g2_decap_8
XFILLER_14_245 VDD VSS sg13g2_fill_2
XFILLER_70_852 VDD VSS sg13g2_decap_4
XFILLER_14_267 VDD VSS sg13g2_fill_2
XFILLER_14_278 VDD VSS sg13g2_decap_8
XFILLER_30_716 VDD VSS sg13g2_decap_8
XFILLER_42_587 VDD VSS sg13g2_decap_8
XFILLER_70_885 VDD VSS sg13g2_decap_8
XFILLER_80_21 VDD VSS sg13g2_decap_8
XFILLER_9_28 VDD VSS sg13g2_decap_4
Xfanout60 _2389_/Y _3370_/S VDD VSS sg13g2_buf_1
Xfanout71 _3489_/B _3483_/B VDD VSS sg13g2_buf_1
Xfanout82 _3002_/S _3008_/S VDD VSS sg13g2_buf_1
XFILLER_80_98 VDD VSS sg13g2_decap_8
Xfanout93 _2930_/Y fanout93/X VDD VSS sg13g2_buf_1
XFILLER_13_70 VDD VSS sg13g2_decap_4
XFILLER_108_361 VDD VSS sg13g2_decap_8
XFILLER_111_504 VDD VSS sg13g2_fill_1
XFILLER_69_418 VDD VSS sg13g2_decap_8
XFILLER_2_694 VDD VSS sg13g2_decap_8
XFILLER_36_7 VDD VSS sg13g2_decap_8
XFILLER_77_440 VDD VSS sg13g2_decap_8
XFILLER_96_248 VDD VSS sg13g2_decap_8
XFILLER_49_164 VDD VSS sg13g2_decap_8
XFILLER_64_101 VDD VSS sg13g2_decap_8
XFILLER_37_337 VDD VSS sg13g2_decap_8
XFILLER_65_668 VDD VSS sg13g2_decap_8
XFILLER_33_521 VDD VSS sg13g2_decap_8
XFILLER_52_329 VDD VSS sg13g2_fill_1
X_4920_ fanout262/X VSS VDD _4920_/D _4920_/Q clkload5/A sg13g2_dfrbpq_1
XFILLER_92_487 VDD VSS sg13g2_decap_8
XFILLER_21_705 VDD VSS sg13g2_decap_8
X_4851_ fanout328/X VSS VDD _4851_/D _4851_/Q _4955_/CLK sg13g2_dfrbpq_1
XFILLER_21_727 VDD VSS sg13g2_decap_8
XFILLER_33_576 VDD VSS sg13g2_decap_4
XFILLER_61_885 VDD VSS sg13g2_decap_4
X_3802_ _3847_/B _3802_/A _3841_/B VDD VSS sg13g2_nand2_1
XFILLER_20_248 VDD VSS sg13g2_decap_4
X_4782_ fanout249/X VSS VDD _4782_/D _4782_/Q clkload0/A sg13g2_dfrbpq_1
X_3733_ _3809_/A _3792_/B _3733_/B VDD VSS sg13g2_xnor2_1
X_3664_ _3664_/A _3697_/A _3664_/Y VDD VSS sg13g2_nor2_1
XFILLER_62_0 VDD VSS sg13g2_decap_8
Xclkload30 clkload30/Y _4978_/CLK VDD VSS sg13g2_inv_2
X_2615_ _3268_/A _2615_/C _2615_/A _3275_/B VDD VSS _2615_/D sg13g2_nand4_1
X_3595_ _3595_/A _3601_/B _3596_/C VDD VSS sg13g2_nor2_1
X_2546_ _4876_/Q _2547_/A _4875_/Q _2552_/B VDD VSS _2546_/D sg13g2_nand4_1
XFILLER_114_386 VDD VSS sg13g2_decap_8
X_2477_ _2486_/A _3901_/A _3901_/C VDD VSS sg13g2_nand2b_1
XFILLER_29_805 VDD VSS sg13g2_decap_8
X_4216_ _4243_/B1 VDD _4216_/Y VSS _4213_/Y _4214_/Y sg13g2_o21ai_1
XFILLER_87_259 VDD VSS sg13g2_decap_4
XFILLER_56_602 VDD VSS sg13g2_fill_2
XFILLER_84_900 VDD VSS sg13g2_decap_4
X_4147_ _4147_/B1 VDD _4147_/Y VSS _4245_/A1 _4141_/X sg13g2_o21ai_1
XFILLER_28_337 VDD VSS sg13g2_decap_8
XFILLER_55_123 VDD VSS sg13g2_decap_8
XFILLER_55_134 VDD VSS sg13g2_fill_1
XFILLER_95_270 VDD VSS sg13g2_fill_1
XFILLER_37_871 VDD VSS sg13g2_decap_8
X_4078_ _4078_/Y _4078_/A _4078_/B VDD VSS sg13g2_nand2_1
X_3029_ hold950/X hold795/X _3029_/S _4455_/D VDD VSS sg13g2_mux2_1
XFILLER_12_716 VDD VSS sg13g2_decap_8
XFILLER_34_69 VDD VSS sg13g2_decap_8
XFILLER_12_749 VDD VSS sg13g2_decap_8
Xclkload2 clkload2/Y clkload2/A VDD VSS sg13g2_inv_2
XFILLER_20_782 VDD VSS sg13g2_decap_8
XFILLER_50_35 VDD VSS sg13g2_decap_8
XFILLER_106_832 VDD VSS sg13g2_decap_8
XFILLER_79_716 VDD VSS sg13g2_decap_8
XFILLER_59_55 VDD VSS sg13g2_decap_8
XFILLER_78_215 VDD VSS sg13g2_decap_8
XFILLER_79_749 VDD VSS sg13g2_decap_8
Xfanout250 fanout256/X fanout250/X VDD VSS sg13g2_buf_1
Xfanout261 fanout262/X fanout261/X VDD VSS sg13g2_buf_1
Xfanout272 fanout273/X fanout272/X VDD VSS sg13g2_buf_1
Xfanout283 fanout294/X fanout283/X VDD VSS sg13g2_buf_1
XFILLER_87_782 VDD VSS sg13g2_fill_1
XFILLER_19_326 VDD VSS sg13g2_decap_8
XFILLER_59_484 VDD VSS sg13g2_decap_8
XFILLER_74_410 VDD VSS sg13g2_decap_4
Xfanout294 fanout295/X fanout294/X VDD VSS sg13g2_buf_1
XFILLER_87_793 VDD VSS sg13g2_decap_8
XFILLER_46_145 VDD VSS sg13g2_fill_1
XFILLER_47_679 VDD VSS sg13g2_decap_4
XFILLER_75_65 VDD VSS sg13g2_decap_8
XFILLER_75_98 VDD VSS sg13g2_decap_8
XFILLER_90_925 VDD VSS sg13g2_fill_1
XFILLER_43_830 VDD VSS sg13g2_decap_8
XFILLER_15_543 VDD VSS sg13g2_decap_8
XFILLER_27_392 VDD VSS sg13g2_fill_2
XFILLER_55_690 VDD VSS sg13g2_decap_8
XFILLER_61_137 VDD VSS sg13g2_decap_8
XFILLER_91_42 VDD VSS sg13g2_decap_8
XFILLER_30_502 VDD VSS sg13g2_decap_8
XFILLER_30_546 VDD VSS sg13g2_fill_1
XFILLER_24_80 VDD VSS sg13g2_fill_1
XFILLER_7_731 VDD VSS sg13g2_fill_1
Xhold709 _2791_/Y VDD VSS _4869_/D sg13g2_dlygate4sd3_1
XFILLER_115_117 VDD VSS sg13g2_fill_1
XFILLER_7_797 VDD VSS sg13g2_decap_8
X_2400_ VSS VDD _2400_/X _4923_/Q _4924_/Q sg13g2_or2_1
X_3380_ _3399_/B VDD _3381_/C VSS _3337_/A _3396_/B sg13g2_o21ai_1
X_2331_ VDD _3511_/A _2654_/A VSS sg13g2_inv_1
XFILLER_112_868 VDD VSS sg13g2_decap_4
XFILLER_69_259 VDD VSS sg13g2_decap_8
X_2262_ VDD _2262_/Y _2262_/A VSS sg13g2_inv_1
XFILLER_97_546 VDD VSS sg13g2_decap_8
XFILLER_111_378 VDD VSS sg13g2_decap_8
XFILLER_111_389 VDD VSS sg13g2_fill_2
Xhold1409 _3229_/X VDD VSS _3230_/B sg13g2_dlygate4sd3_1
X_4001_ _4001_/Y _4001_/A _4003_/B VDD VSS sg13g2_nand2_1
XFILLER_65_432 VDD VSS sg13g2_fill_1
XFILLER_18_370 VDD VSS sg13g2_decap_8
XFILLER_37_189 VDD VSS sg13g2_fill_2
XFILLER_52_137 VDD VSS sg13g2_decap_8
X_4903_ fanout247/X VSS VDD _4903_/D _4903_/Q _4904_/CLK sg13g2_dfrbpq_1
XFILLER_33_395 VDD VSS sg13g2_decap_8
X_4834_ fanout270/X VSS VDD _4834_/D _4834_/Q _4841_/CLK sg13g2_dfrbpq_1
X_4765_ fanout249/X VSS VDD _4765_/D _4765_/Q clkload1/A sg13g2_dfrbpq_1
X_3716_ VDD VSS _3668_/Y _3664_/Y _3667_/B _3698_/C _3719_/B _3686_/C sg13g2_a221oi_1
X_4696_ fanout302/X VSS VDD _4696_/D _4696_/Q _4884_/CLK sg13g2_dfrbpq_1
XFILLER_106_128 VDD VSS sg13g2_decap_8
XFILLER_20_49 VDD VSS sg13g2_decap_4
X_3647_ _3646_/Y VDD _3647_/Y VSS _3690_/A _3652_/S sg13g2_o21ai_1
XFILLER_115_662 VDD VSS sg13g2_fill_2
X_3578_ _4863_/Q _3595_/A _3590_/C _3582_/C _3581_/A VDD VSS sg13g2_nor4_1
XFILLER_0_417 VDD VSS sg13g2_decap_8
XFILLER_115_673 VDD VSS sg13g2_decap_8
X_2529_ _4769_/Q _4770_/Q _3802_/A VDD VSS sg13g2_nor2_1
XFILLER_103_846 VDD VSS sg13g2_decap_8
XFILLER_29_25 VDD VSS sg13g2_decap_8
XFILLER_102_356 VDD VSS sg13g2_decap_8
XFILLER_103_879 VDD VSS sg13g2_fill_2
XFILLER_69_760 VDD VSS sg13g2_decap_8
XFILLER_29_624 VDD VSS sg13g2_decap_8
XFILLER_96_590 VDD VSS sg13g2_decap_8
XFILLER_43_104 VDD VSS sg13g2_decap_8
XFILLER_44_638 VDD VSS sg13g2_decap_8
XFILLER_71_446 VDD VSS sg13g2_decap_8
XFILLER_101_30 VDD VSS sg13g2_fill_1
XFILLER_25_874 VDD VSS sg13g2_fill_2
XFILLER_71_479 VDD VSS sg13g2_decap_8
XFILLER_12_535 VDD VSS sg13g2_decap_8
XFILLER_52_693 VDD VSS sg13g2_decap_4
XFILLER_101_96 VDD VSS sg13g2_decap_8
XFILLER_61_56 VDD VSS sg13g2_decap_8
XFILLER_3_200 VDD VSS sg13g2_decap_8
XFILLER_3_244 VDD VSS sg13g2_fill_1
XFILLER_4_767 VDD VSS sg13g2_decap_8
XFILLER_106_695 VDD VSS sg13g2_decap_8
XFILLER_3_266 VDD VSS sg13g2_fill_2
XFILLER_79_513 VDD VSS sg13g2_decap_8
XFILLER_66_218 VDD VSS sg13g2_decap_8
XFILLER_67_719 VDD VSS sg13g2_fill_1
XFILLER_94_527 VDD VSS sg13g2_fill_2
XFILLER_94_516 VDD VSS sg13g2_fill_1
XFILLER_94_538 VDD VSS sg13g2_decap_8
XFILLER_19_134 VDD VSS sg13g2_fill_1
XFILLER_62_402 VDD VSS sg13g2_decap_8
XFILLER_74_262 VDD VSS sg13g2_decap_8
XFILLER_75_785 VDD VSS sg13g2_fill_1
XFILLER_28_690 VDD VSS sg13g2_decap_8
XFILLER_16_874 VDD VSS sg13g2_decap_8
XFILLER_16_885 VDD VSS sg13g2_fill_1
XFILLER_62_479 VDD VSS sg13g2_decap_8
XFILLER_43_693 VDD VSS sg13g2_decap_8
X_2880_ hold858/X _3088_/A0 _2900_/S _2880_/X VDD VSS sg13g2_mux2_1
XFILLER_42_192 VDD VSS sg13g2_fill_2
XFILLER_30_398 VDD VSS sg13g2_decap_8
X_4550_ fanout320/X VSS VDD _4550_/D _4550_/Q _4961_/CLK sg13g2_dfrbpq_1
XFILLER_116_415 VDD VSS sg13g2_decap_8
X_4481_ fanout306/X VSS VDD _4481_/D _4481_/Q _4975_/CLK sg13g2_dfrbpq_1
X_3501_ VDD VSS _2708_/A _3500_/Y _2708_/B _3501_/A1 _3504_/C _2698_/B sg13g2_a221oi_1
Xhold539 _4849_/Q VDD VSS _4847_/D sg13g2_dlygate4sd3_1
X_3432_ _3431_/Y VDD _4653_/D VSS _2266_/Y _3447_/C sg13g2_o21ai_1
X_3363_ _3457_/A _3363_/A1 _3370_/S _4639_/D VDD VSS sg13g2_mux2_1
XFILLER_97_310 VDD VSS sg13g2_decap_8
XFILLER_111_120 VDD VSS sg13g2_decap_8
XFILLER_58_708 VDD VSS sg13g2_decap_8
XFILLER_100_805 VDD VSS sg13g2_decap_8
XFILLER_25_0 VDD VSS sg13g2_decap_8
Xhold1206 _3119_/X VDD VSS _4543_/D sg13g2_dlygate4sd3_1
X_3294_ _3295_/B _3294_/A _3294_/B VDD VSS sg13g2_xnor2_1
X_2314_ VDD _3325_/A _3413_/C VSS sg13g2_inv_1
XFILLER_85_505 VDD VSS sg13g2_decap_4
XFILLER_38_421 VDD VSS sg13g2_fill_1
XFILLER_39_922 VDD VSS sg13g2_decap_4
Xhold1217 _4701_/Q VDD VSS _3539_/A0 sg13g2_dlygate4sd3_1
Xhold1228 _2733_/Y VDD VSS _2734_/C sg13g2_dlygate4sd3_1
Xhold1239 _4262_/Q VDD VSS _2825_/A0 sg13g2_dlygate4sd3_1
X_2245_ VDD _2245_/Y _3899_/A VSS sg13g2_inv_1
XFILLER_38_432 VDD VSS sg13g2_decap_4
XFILLER_54_903 VDD VSS sg13g2_decap_8
XFILLER_38_476 VDD VSS sg13g2_decap_4
XFILLER_53_402 VDD VSS sg13g2_decap_8
XFILLER_65_262 VDD VSS sg13g2_decap_4
XFILLER_66_796 VDD VSS sg13g2_decap_8
XFILLER_93_571 VDD VSS sg13g2_decap_8
XFILLER_93_560 VDD VSS sg13g2_decap_8
XFILLER_19_690 VDD VSS sg13g2_decap_8
XFILLER_15_27 VDD VSS sg13g2_fill_2
XFILLER_33_170 VDD VSS sg13g2_decap_8
XFILLER_21_343 VDD VSS sg13g2_decap_8
XFILLER_21_354 VDD VSS sg13g2_fill_2
Xclkbuf_leaf_60_clk clkbuf_4_2_0_clk/X clkload7/A VDD VSS sg13g2_buf_8
X_4817_ fanout293/X VSS VDD _4817_/D _4817_/Q _4817_/CLK sg13g2_dfrbpq_1
X_4748_ fanout273/X VSS VDD _4748_/D _4748_/Q _4749_/CLK sg13g2_dfrbpq_1
X_4679_ fanout255/X VSS VDD _4679_/D _4679_/Q clkload4/A sg13g2_dfrbpq_1
XFILLER_103_7 VDD VSS sg13g2_decap_8
Xoutput15 _2604_/Y ld4 VDD VSS sg13g2_buf_1
XFILLER_0_203 VDD VSS sg13g2_decap_8
XFILLER_1_726 VDD VSS sg13g2_decap_8
XFILLER_115_481 VDD VSS sg13g2_decap_8
XFILLER_89_866 VDD VSS sg13g2_decap_8
XFILLER_103_676 VDD VSS sg13g2_decap_8
XFILLER_88_376 VDD VSS sg13g2_decap_8
XFILLER_102_164 VDD VSS sg13g2_decap_8
XFILLER_56_56 VDD VSS sg13g2_decap_8
XFILLER_91_508 VDD VSS sg13g2_fill_1
XFILLER_17_638 VDD VSS sg13g2_fill_2
XFILLER_29_465 VDD VSS sg13g2_fill_2
XFILLER_45_925 VDD VSS sg13g2_fill_1
XFILLER_56_273 VDD VSS sg13g2_decap_8
XFILLER_84_582 VDD VSS sg13g2_fill_1
XFILLER_16_137 VDD VSS sg13g2_decap_8
XFILLER_71_221 VDD VSS sg13g2_decap_8
XFILLER_72_744 VDD VSS sg13g2_decap_8
XFILLER_112_62 VDD VSS sg13g2_decap_4
XFILLER_16_159 VDD VSS sg13g2_decap_8
XFILLER_71_254 VDD VSS sg13g2_fill_1
XFILLER_72_44 VDD VSS sg13g2_decap_8
XFILLER_12_343 VDD VSS sg13g2_fill_2
Xclkbuf_leaf_51_clk clkbuf_4_8_0_clk/X _4397_/CLK VDD VSS sg13g2_buf_8
XFILLER_8_336 VDD VSS sg13g2_decap_8
XFILLER_106_470 VDD VSS sg13g2_decap_8
XFILLER_21_92 VDD VSS sg13g2_decap_8
XFILLER_4_586 VDD VSS sg13g2_fill_2
XFILLER_97_63 VDD VSS sg13g2_fill_2
XFILLER_0_781 VDD VSS sg13g2_decap_8
XFILLER_39_218 VDD VSS sg13g2_decap_8
XFILLER_94_313 VDD VSS sg13g2_decap_8
XFILLER_36_914 VDD VSS sg13g2_decap_8
XFILLER_36_925 VDD VSS sg13g2_fill_1
XFILLER_47_251 VDD VSS sg13g2_decap_8
XFILLER_63_722 VDD VSS sg13g2_decap_8
XFILLER_94_379 VDD VSS sg13g2_decap_4
XFILLER_62_221 VDD VSS sg13g2_decap_8
X_3981_ _3981_/Y _3981_/A _3985_/B VDD VSS sg13g2_nand2_1
X_2932_ _2932_/A0 _3087_/A0 _2955_/S _4362_/D VDD VSS sg13g2_mux2_1
Xclkbuf_leaf_42_clk clkbuf_4_11_0_clk/X _4975_/CLK VDD VSS sg13g2_buf_8
X_2863_ _2863_/A0 _3098_/A0 _2874_/S _4298_/D VDD VSS sg13g2_mux2_1
XFILLER_30_184 VDD VSS sg13g2_fill_1
XFILLER_30_195 VDD VSS sg13g2_fill_1
X_4602_ fanout277/X VSS VDD _4602_/D _4602_/Q _4950_/CLK sg13g2_dfrbpq_1
X_2794_ _2809_/A VDD _2794_/Y VSS _2414_/B _2793_/B sg13g2_o21ai_1
XFILLER_7_61 VDD VSS sg13g2_decap_8
X_4533_ fanout299/X VSS VDD _4533_/D _4533_/Q _4971_/CLK sg13g2_dfrbpq_1
XFILLER_104_407 VDD VSS sg13g2_decap_8
XFILLER_116_256 VDD VSS sg13g2_decap_8
X_4464_ fanout321/X VSS VDD _4464_/D _4464_/Q _4979_/CLK sg13g2_dfrbpq_1
X_4395_ _4395_/RESET_B VSS VDD _4395_/D _4395_/Q _4964_/CLK sg13g2_dfrbpq_1
X_3415_ _3415_/A _3415_/B _3416_/C VDD VSS sg13g2_nor2_1
XFILLER_98_641 VDD VSS sg13g2_decap_8
X_3346_ VSS VDD _3348_/A _3469_/C _3346_/Y _3345_/Y sg13g2_a21oi_1
XFILLER_98_663 VDD VSS sg13g2_decap_8
XFILLER_86_803 VDD VSS sg13g2_decap_8
XFILLER_100_624 VDD VSS sg13g2_decap_8
XFILLER_112_473 VDD VSS sg13g2_fill_2
XFILLER_85_313 VDD VSS sg13g2_fill_2
Xhold1003 _4487_/Q VDD VSS _3061_/A1 sg13g2_dlygate4sd3_1
Xhold1014 _2961_/X VDD VSS _4390_/D sg13g2_dlygate4sd3_1
XFILLER_97_195 VDD VSS sg13g2_decap_8
XFILLER_85_346 VDD VSS sg13g2_decap_8
Xhold1025 _4369_/Q VDD VSS _2939_/A0 sg13g2_dlygate4sd3_1
Xhold1036 _4538_/Q VDD VSS _3114_/A1 sg13g2_dlygate4sd3_1
Xhold1047 _4702_/Q VDD VSS _3540_/A0 sg13g2_dlygate4sd3_1
Xhold1058 _2834_/X VDD VSS _4271_/D sg13g2_dlygate4sd3_1
X_3277_ _2616_/B VDD _3278_/C VSS _3275_/A _3275_/B sg13g2_o21ai_1
XFILLER_86_869 VDD VSS sg13g2_decap_8
XFILLER_26_402 VDD VSS sg13g2_decap_8
XFILLER_27_925 VDD VSS sg13g2_fill_1
Xhold1069 _4428_/Q VDD VSS _3001_/A0 sg13g2_dlygate4sd3_1
XFILLER_94_891 VDD VSS sg13g2_fill_2
XFILLER_14_619 VDD VSS sg13g2_decap_8
XFILLER_26_457 VDD VSS sg13g2_decap_8
XFILLER_41_405 VDD VSS sg13g2_fill_2
XFILLER_42_917 VDD VSS sg13g2_decap_8
XFILLER_41_416 VDD VSS sg13g2_fill_1
XFILLER_42_14 VDD VSS sg13g2_fill_2
Xclkbuf_leaf_33_clk clkbuf_4_14_0_clk/X _4729_/CLK VDD VSS sg13g2_buf_8
XFILLER_10_825 VDD VSS sg13g2_decap_8
XFILLER_22_696 VDD VSS sg13g2_decap_8
XFILLER_42_58 VDD VSS sg13g2_decap_8
XFILLER_107_267 VDD VSS sg13g2_fill_2
X_4297__429 VDD VSS _4297_/RESET_B sg13g2_tiehi
Xhold881 _2989_/X VDD VSS _4416_/D sg13g2_dlygate4sd3_1
Xhold870 _4395_/Q VDD VSS hold870/X sg13g2_dlygate4sd3_1
XFILLER_1_545 VDD VSS sg13g2_decap_8
Xhold892 _4776_/Q VDD VSS _2324_/A sg13g2_dlygate4sd3_1
XFILLER_89_652 VDD VSS sg13g2_fill_2
XFILLER_67_77 VDD VSS sg13g2_decap_8
XFILLER_76_357 VDD VSS sg13g2_fill_2
XFILLER_29_240 VDD VSS sg13g2_decap_8
XFILLER_57_571 VDD VSS sg13g2_decap_8
Xhold1570 _4861_/Q VDD VSS _2708_/A sg13g2_dlygate4sd3_1
XFILLER_72_530 VDD VSS sg13g2_decap_8
Xhold1581 _4564_/Q VDD VSS _3154_/A sg13g2_dlygate4sd3_1
Xhold1592 _4805_/Q VDD VSS _3886_/A sg13g2_dlygate4sd3_1
XFILLER_17_457 VDD VSS sg13g2_decap_8
XFILLER_44_243 VDD VSS sg13g2_decap_4
XFILLER_13_641 VDD VSS sg13g2_decap_8
XFILLER_60_769 VDD VSS sg13g2_decap_8
Xclkbuf_leaf_24_clk clkbuf_4_12_0_clk/X _4527_/CLK VDD VSS sg13g2_buf_8
XFILLER_9_634 VDD VSS sg13g2_fill_1
XFILLER_12_173 VDD VSS sg13g2_fill_2
XFILLER_66_7 VDD VSS sg13g2_decap_8
XFILLER_8_188 VDD VSS sg13g2_fill_1
XFILLER_5_851 VDD VSS sg13g2_decap_8
XFILLER_4_361 VDD VSS sg13g2_decap_4
XFILLER_114_749 VDD VSS sg13g2_decap_8
X_4395__531 VDD VSS _4395_/RESET_B sg13g2_tiehi
X_4180_ _4179_/Y VDD _4971_/D VSS _4177_/Y _4178_/Y sg13g2_o21ai_1
X_3200_ _3200_/Y _3200_/A _3200_/B VDD VSS sg13g2_xnor2_1
XFILLER_68_825 VDD VSS sg13g2_decap_4
X_3131_ _3130_/Y VDD _3131_/Y VSS _4626_/Q _3142_/B sg13g2_o21ai_1
XFILLER_79_195 VDD VSS sg13g2_decap_8
XFILLER_83_806 VDD VSS sg13g2_decap_8
XFILLER_36_711 VDD VSS sg13g2_decap_8
XFILLER_67_368 VDD VSS sg13g2_decap_8
X_3062_ _4044_/B hold869/X _3084_/S _4488_/D VDD VSS sg13g2_mux2_1
XFILLER_94_187 VDD VSS sg13g2_decap_8
XFILLER_36_788 VDD VSS sg13g2_decap_8
XFILLER_51_703 VDD VSS sg13g2_decap_8
XFILLER_35_287 VDD VSS sg13g2_decap_8
XFILLER_90_382 VDD VSS sg13g2_decap_8
XFILLER_50_235 VDD VSS sg13g2_decap_8
XFILLER_51_769 VDD VSS sg13g2_decap_4
Xclkbuf_leaf_15_clk clkbuf_4_5_0_clk/X _4619_/CLK VDD VSS sg13g2_buf_8
X_3964_ _3964_/Y input6/X _4848_/D VDD VSS sg13g2_nand2_1
XFILLER_92_0 VDD VSS sg13g2_decap_8
X_3895_ _3895_/Y _3911_/B _3899_/C VDD VSS sg13g2_nand2_1
X_2915_ _2915_/A0 _3021_/A1 _2926_/S _2915_/X VDD VSS sg13g2_mux2_1
X_2846_ _2846_/A0 _3032_/A1 _2846_/S _2846_/X VDD VSS sg13g2_mux2_1
XFILLER_12_28 VDD VSS sg13g2_decap_8
X_2777_ _2780_/C _2777_/A _2778_/B VDD VSS sg13g2_xor2_1
XFILLER_2_309 VDD VSS sg13g2_decap_8
X_4516_ fanout285/X VSS VDD _4516_/D _4516_/Q _4559_/CLK sg13g2_dfrbpq_1
X_4447_ _4447_/RESET_B VSS VDD _4447_/D _4447_/Q _4960_/CLK sg13g2_dfrbpq_1
XFILLER_85_110 VDD VSS sg13g2_decap_8
X_4378_ _4378_/RESET_B VSS VDD _4378_/D _4378_/Q _4729_/CLK sg13g2_dfrbpq_1
XFILLER_98_482 VDD VSS sg13g2_decap_8
XFILLER_37_14 VDD VSS sg13g2_decap_8
X_3329_ _3329_/X _3329_/A _4782_/Q _4783_/Q VDD VSS sg13g2_and3_1
XFILLER_74_828 VDD VSS sg13g2_decap_4
XFILLER_27_788 VDD VSS sg13g2_decap_8
XFILLER_82_850 VDD VSS sg13g2_decap_8
XFILLER_53_35 VDD VSS sg13g2_decap_8
XFILLER_53_68 VDD VSS sg13g2_decap_4
XFILLER_108_532 VDD VSS sg13g2_decap_8
XFILLER_6_648 VDD VSS sg13g2_decap_8
XFILLER_108_587 VDD VSS sg13g2_decap_4
XFILLER_78_21 VDD VSS sg13g2_decap_8
XFILLER_78_32 VDD VSS sg13g2_fill_1
XFILLER_104_760 VDD VSS sg13g2_decap_8
XFILLER_1_331 VDD VSS sg13g2_decap_8
XFILLER_2_876 VDD VSS sg13g2_decap_8
XFILLER_96_419 VDD VSS sg13g2_decap_8
XFILLER_49_346 VDD VSS sg13g2_fill_1
XFILLER_49_357 VDD VSS sg13g2_decap_4
XFILLER_76_121 VDD VSS sg13g2_fill_1
XFILLER_76_143 VDD VSS sg13g2_decap_8
XFILLER_77_644 VDD VSS sg13g2_decap_8
XFILLER_94_42 VDD VSS sg13g2_fill_1
XFILLER_94_86 VDD VSS sg13g2_decap_8
XFILLER_17_254 VDD VSS sg13g2_fill_1
XFILLER_45_563 VDD VSS sg13g2_decap_4
XFILLER_92_669 VDD VSS sg13g2_fill_1
XFILLER_91_157 VDD VSS sg13g2_decap_8
XFILLER_17_287 VDD VSS sg13g2_decap_8
XFILLER_27_91 VDD VSS sg13g2_decap_4
XFILLER_60_522 VDD VSS sg13g2_fill_1
XFILLER_17_298 VDD VSS sg13g2_fill_2
XFILLER_32_224 VDD VSS sg13g2_decap_8
XFILLER_60_566 VDD VSS sg13g2_fill_2
XFILLER_20_419 VDD VSS sg13g2_decap_8
XFILLER_41_791 VDD VSS sg13g2_decap_4
X_2700_ _2700_/A _3612_/A _2702_/C VDD VSS sg13g2_nor2_1
X_3680_ _3680_/Y _4735_/Q _3680_/B VDD VSS sg13g2_xnor2_1
X_2631_ _2627_/Y VDD _4843_/D VSS _2635_/B _2630_/Y sg13g2_o21ai_1
X_2562_ VDD _2563_/B _2572_/A VSS sg13g2_inv_1
X_4301_ _4301_/RESET_B VSS VDD _4301_/D _4301_/Q _4972_/CLK sg13g2_dfrbpq_1
X_4232_ _4232_/B1 VDD _4232_/Y VSS _4241_/A1 _4458_/Q sg13g2_o21ai_1
X_2493_ _4724_/Q _2686_/B _4728_/Q _4729_/Q _2692_/A VDD VSS sg13g2_or4_1
XFILLER_101_207 VDD VSS sg13g2_fill_2
Xclkbuf_leaf_4_clk clkbuf_4_1_0_clk/X _4673_/CLK VDD VSS sg13g2_buf_8
XFILLER_99_279 VDD VSS sg13g2_fill_1
XFILLER_68_666 VDD VSS sg13g2_decap_8
X_4163_ _4162_/Y VDD _4169_/B VSS _4159_/Y _4160_/Y sg13g2_o21ai_1
XFILLER_55_316 VDD VSS sg13g2_decap_8
XFILLER_67_176 VDD VSS sg13g2_decap_8
X_4094_ _4093_/Y VDD _4100_/B VSS _4090_/Y _4091_/Y sg13g2_o21ai_1
X_3114_ _3648_/A1 _3114_/A1 _3136_/B _4538_/D VDD VSS sg13g2_mux2_1
X_3045_ _3532_/A1 _4496_/Q _3056_/S _3045_/X VDD VSS sg13g2_mux2_1
XFILLER_82_157 VDD VSS sg13g2_decap_8
XFILLER_51_500 VDD VSS sg13g2_fill_1
XFILLER_91_680 VDD VSS sg13g2_decap_8
XFILLER_12_909 VDD VSS sg13g2_decap_8
XFILLER_24_758 VDD VSS sg13g2_decap_8
X_4287__439 VDD VSS _4287_/RESET_B sg13g2_tiehi
XFILLER_90_190 VDD VSS sg13g2_decap_8
XFILLER_23_257 VDD VSS sg13g2_decap_4
XFILLER_51_588 VDD VSS sg13g2_decap_8
X_3947_ _3947_/A _3946_/Y _4820_/D VDD VSS sg13g2_nor2b_1
X_3878_ VSS VDD _4802_/D _3878_/B _3878_/A sg13g2_or2_1
X_2829_ _2829_/A0 _3091_/A0 _2847_/S _2829_/X VDD VSS sg13g2_mux2_1
XFILLER_105_546 VDD VSS sg13g2_decap_8
XFILLER_99_791 VDD VSS sg13g2_decap_4
XFILLER_59_644 VDD VSS sg13g2_decap_8
XFILLER_59_688 VDD VSS sg13g2_decap_4
XFILLER_74_603 VDD VSS sg13g2_decap_4
XFILLER_86_452 VDD VSS sg13g2_decap_8
XFILLER_104_63 VDD VSS sg13g2_decap_8
XFILLER_73_113 VDD VSS sg13g2_decap_8
XFILLER_27_530 VDD VSS sg13g2_decap_8
XFILLER_55_861 VDD VSS sg13g2_decap_8
XFILLER_61_308 VDD VSS sg13g2_decap_8
XFILLER_14_213 VDD VSS sg13g2_decap_8
XFILLER_27_596 VDD VSS sg13g2_decap_8
XFILLER_64_56 VDD VSS sg13g2_decap_8
XFILLER_70_831 VDD VSS sg13g2_decap_8
XFILLER_73_179 VDD VSS sg13g2_fill_2
XFILLER_82_680 VDD VSS sg13g2_decap_8
XFILLER_42_566 VDD VSS sg13g2_decap_8
Xfanout50 _3444_/A2 _3471_/C VDD VSS sg13g2_buf_1
Xfanout61 _3610_/B _3601_/B VDD VSS sg13g2_buf_1
Xfanout72 _3306_/X _3489_/B VDD VSS sg13g2_buf_1
Xfanout83 _2983_/Y _3002_/S VDD VSS sg13g2_buf_1
XFILLER_10_430 VDD VSS sg13g2_decap_8
XFILLER_80_77 VDD VSS sg13g2_decap_8
Xfanout94 fanout98/X _2926_/S VDD VSS sg13g2_buf_1
XFILLER_10_474 VDD VSS sg13g2_decap_8
XFILLER_10_485 VDD VSS sg13g2_fill_1
XFILLER_13_82 VDD VSS sg13g2_fill_1
XFILLER_6_489 VDD VSS sg13g2_decap_8
X_4392__534 VDD VSS _4392_/RESET_B sg13g2_tiehi
XFILLER_97_739 VDD VSS sg13g2_decap_8
XFILLER_96_227 VDD VSS sg13g2_decap_8
XFILLER_29_7 VDD VSS sg13g2_fill_2
XFILLER_37_316 VDD VSS sg13g2_decap_8
XFILLER_65_647 VDD VSS sg13g2_decap_8
XFILLER_77_496 VDD VSS sg13g2_fill_2
XFILLER_18_541 VDD VSS sg13g2_fill_1
XFILLER_53_809 VDD VSS sg13g2_decap_8
XFILLER_92_466 VDD VSS sg13g2_decap_8
XFILLER_92_455 VDD VSS sg13g2_fill_2
XFILLER_92_444 VDD VSS sg13g2_decap_8
XFILLER_33_511 VDD VSS sg13g2_fill_1
XFILLER_46_883 VDD VSS sg13g2_fill_2
XFILLER_61_864 VDD VSS sg13g2_decap_8
X_4850_ fanout305/X VSS VDD _4850_/D _4850_/Q _4974_/CLK sg13g2_dfrbpq_1
XFILLER_60_363 VDD VSS sg13g2_fill_2
X_3801_ _3844_/B _3841_/B _4769_/Q VDD VSS sg13g2_nand2b_1
XFILLER_14_791 VDD VSS sg13g2_decap_8
XFILLER_60_385 VDD VSS sg13g2_decap_8
X_4781_ fanout259/X VSS VDD _4781_/D _4781_/Q clkload0/A sg13g2_dfrbpq_1
X_3732_ _3792_/B _4758_/Q _3811_/A VDD VSS sg13g2_nor2_1
Xclkload20 VDD clkload20/Y _4966_/CLK VSS sg13g2_inv_1
X_3663_ _3706_/A _3717_/A _3697_/A VDD VSS sg13g2_nor2b_1
XFILLER_9_294 VDD VSS sg13g2_decap_8
XFILLER_115_811 VDD VSS sg13g2_decap_8
Xclkload31 clkload31/Y _4973_/CLK VDD VSS sg13g2_inv_2
X_2614_ _4614_/Q _3273_/B _2615_/D VDD VSS sg13g2_nor2_1
XFILLER_55_0 VDD VSS sg13g2_decap_8
X_3594_ VSS VDD _3598_/A _3597_/B _3597_/A sg13g2_or2_1
XFILLER_115_877 VDD VSS sg13g2_decap_4
X_2545_ _2547_/B _2545_/B _2545_/X VDD VSS sg13g2_and2_1
X_2476_ _4805_/Q _2476_/C _2476_/A _3901_/C VDD VSS _3889_/C sg13g2_nand4_1
XFILLER_88_739 VDD VSS sg13g2_decap_8
XFILLER_102_549 VDD VSS sg13g2_decap_8
X_4215_ _4381_/Q _4406_/Q _4251_/S _4215_/X VDD VSS sg13g2_mux2_1
XFILLER_87_238 VDD VSS sg13g2_decap_8
X_4146_ VSS VDD _4244_/A1 _4144_/X _4146_/Y _4145_/Y sg13g2_a21oi_1
XFILLER_18_49 VDD VSS sg13g2_decap_8
XFILLER_28_327 VDD VSS sg13g2_fill_1
XFILLER_56_636 VDD VSS sg13g2_decap_8
XFILLER_37_850 VDD VSS sg13g2_decap_8
XFILLER_43_308 VDD VSS sg13g2_decap_8
XFILLER_71_617 VDD VSS sg13g2_fill_2
X_4077_ VSS VDD _4190_/A1 _4073_/X _4077_/Y _4076_/Y sg13g2_a21oi_1
X_3028_ _3028_/A0 hold810/X _3028_/S _4454_/D VDD VSS sg13g2_mux2_1
XFILLER_24_555 VDD VSS sg13g2_decap_8
XFILLER_70_149 VDD VSS sg13g2_decap_8
X_4979_ fanout321/X VSS VDD _4979_/D _4979_/Q _4979_/CLK sg13g2_dfrbpq_1
XFILLER_11_249 VDD VSS sg13g2_decap_8
XFILLER_20_761 VDD VSS sg13g2_decap_8
XFILLER_7_209 VDD VSS sg13g2_decap_8
Xclkload3 clkload3/Y clkload3/A VDD VSS sg13g2_inv_2
XFILLER_59_34 VDD VSS sg13g2_decap_8
XFILLER_106_888 VDD VSS sg13g2_decap_8
XFILLER_59_67 VDD VSS sg13g2_decap_4
Xfanout240 hold1353/X _3091_/A0 VDD VSS sg13g2_buf_1
XFILLER_94_709 VDD VSS sg13g2_decap_8
XFILLER_115_73 VDD VSS sg13g2_decap_8
Xfanout251 fanout252/X fanout251/X VDD VSS sg13g2_buf_1
Xfanout262 fanout295/X fanout262/X VDD VSS sg13g2_buf_1
Xfanout273 fanout274/X fanout273/X VDD VSS sg13g2_buf_1
XFILLER_87_761 VDD VSS sg13g2_decap_8
XFILLER_75_44 VDD VSS sg13g2_decap_8
Xfanout284 fanout286/X fanout284/X VDD VSS sg13g2_buf_1
Xfanout295 input4/X fanout295/X VDD VSS sg13g2_buf_1
XFILLER_61_105 VDD VSS sg13g2_decap_8
XFILLER_61_116 VDD VSS sg13g2_fill_1
XFILLER_15_522 VDD VSS sg13g2_decap_8
XFILLER_91_76 VDD VSS sg13g2_decap_4
XFILLER_6_242 VDD VSS sg13g2_fill_1
XFILLER_7_776 VDD VSS sg13g2_decap_8
XFILLER_109_693 VDD VSS sg13g2_decap_8
X_4277__449 VDD VSS _4277_/RESET_B sg13g2_tiehi
X_2330_ VDD _3503_/A _2330_/A VSS sg13g2_inv_1
XFILLER_97_525 VDD VSS sg13g2_decap_8
XFILLER_111_324 VDD VSS sg13g2_decap_8
XFILLER_112_847 VDD VSS sg13g2_decap_8
X_2261_ VDD _2261_/Y _4659_/Q VSS sg13g2_inv_1
X_4000_ VSS VDD _3999_/A _4003_/A _4000_/Y _3999_/Y sg13g2_a21oi_1
XFILLER_77_271 VDD VSS sg13g2_decap_4
XFILLER_93_720 VDD VSS sg13g2_fill_1
XFILLER_19_861 VDD VSS sg13g2_decap_8
XFILLER_1_63 VDD VSS sg13g2_decap_4
XFILLER_37_135 VDD VSS sg13g2_decap_8
XFILLER_65_444 VDD VSS sg13g2_decap_8
XFILLER_92_241 VDD VSS sg13g2_decap_8
XFILLER_25_319 VDD VSS sg13g2_fill_1
XFILLER_80_458 VDD VSS sg13g2_decap_8
X_4902_ fanout247/X VSS VDD _4902_/D _4902_/Q _4904_/CLK sg13g2_dfrbpq_1
XFILLER_21_525 VDD VSS sg13g2_decap_8
XFILLER_21_536 VDD VSS sg13g2_fill_1
XFILLER_33_374 VDD VSS sg13g2_decap_8
X_4833_ fanout270/X VSS VDD _4833_/D _4833_/Q _4841_/CLK sg13g2_dfrbpq_1
X_4764_ fanout249/X VSS VDD _4764_/D _4764_/Q clkload1/A sg13g2_dfrbpq_1
X_3715_ VSS VDD _3674_/B _3701_/B _3715_/Y _3726_/B sg13g2_a21oi_1
X_4695_ fanout309/X VSS VDD _4695_/D _4695_/Q _4894_/CLK sg13g2_dfrbpq_1
XFILLER_106_107 VDD VSS sg13g2_fill_1
XFILLER_20_28 VDD VSS sg13g2_decap_8
X_3646_ _3646_/Y _3646_/A _3652_/S VDD VSS sg13g2_nand2_1
XFILLER_115_630 VDD VSS sg13g2_fill_2
XFILLER_115_641 VDD VSS sg13g2_decap_8
XFILLER_1_908 VDD VSS sg13g2_decap_8
X_3577_ _3592_/B VDD _3582_/C VSS _2498_/B _3572_/A sg13g2_o21ai_1
XFILLER_114_162 VDD VSS sg13g2_decap_8
X_2528_ _2527_/X VDD _2528_/Y VSS _4765_/Q _2526_/Y sg13g2_o21ai_1
XFILLER_102_335 VDD VSS sg13g2_decap_8
XFILLER_88_558 VDD VSS sg13g2_decap_8
XFILLER_29_603 VDD VSS sg13g2_decap_8
XFILLER_75_208 VDD VSS sg13g2_fill_2
X_2459_ _4006_/A _4004_/A _2459_/Y VDD VSS sg13g2_nor2_1
XFILLER_84_731 VDD VSS sg13g2_decap_8
XFILLER_28_124 VDD VSS sg13g2_fill_1
XFILLER_56_455 VDD VSS sg13g2_decap_8
XFILLER_72_915 VDD VSS sg13g2_decap_8
X_4129_ _4236_/B1 VDD _4129_/Y VSS _4236_/A1 _4123_/X sg13g2_o21ai_1
XFILLER_44_617 VDD VSS sg13g2_decap_8
XFILLER_45_14 VDD VSS sg13g2_decap_8
XFILLER_71_425 VDD VSS sg13g2_decap_8
XFILLER_83_263 VDD VSS sg13g2_decap_8
XFILLER_71_458 VDD VSS sg13g2_decap_8
XFILLER_52_661 VDD VSS sg13g2_fill_2
XFILLER_101_75 VDD VSS sg13g2_decap_8
XFILLER_51_160 VDD VSS sg13g2_decap_8
XFILLER_51_171 VDD VSS sg13g2_decap_4
XFILLER_61_35 VDD VSS sg13g2_decap_8
XFILLER_8_529 VDD VSS sg13g2_decap_8
XFILLER_20_591 VDD VSS sg13g2_decap_8
XFILLER_4_746 VDD VSS sg13g2_decap_8
XFILLER_3_256 VDD VSS sg13g2_fill_1
XFILLER_105_173 VDD VSS sg13g2_decap_8
XFILLER_86_21 VDD VSS sg13g2_decap_8
XFILLER_79_569 VDD VSS sg13g2_decap_8
XFILLER_19_179 VDD VSS sg13g2_decap_8
XFILLER_47_488 VDD VSS sg13g2_decap_8
XFILLER_34_116 VDD VSS sg13g2_decap_8
XFILLER_90_756 VDD VSS sg13g2_fill_2
XFILLER_15_363 VDD VSS sg13g2_decap_8
XFILLER_43_672 VDD VSS sg13g2_decap_8
XFILLER_42_171 VDD VSS sg13g2_decap_8
XFILLER_96_7 VDD VSS sg13g2_decap_8
XFILLER_31_867 VDD VSS sg13g2_decap_4
X_3500_ _3529_/B VDD _3500_/Y VSS _3555_/A _3498_/B sg13g2_o21ai_1
XFILLER_7_584 VDD VSS sg13g2_decap_8
X_4480_ fanout306/X VSS VDD _4480_/D _4480_/Q _4975_/CLK sg13g2_dfrbpq_1
X_3431_ _3453_/B _3471_/C _3431_/A _3431_/Y VDD VSS sg13g2_nand3_1
X_3362_ _3362_/A _3362_/B _3362_/Y VDD VSS sg13g2_nor2_1
XFILLER_98_812 VDD VSS sg13g2_decap_4
X_2313_ VDD _2313_/Y _3329_/A VSS sg13g2_inv_1
XFILLER_97_333 VDD VSS sg13g2_decap_4
XFILLER_112_655 VDD VSS sg13g2_fill_2
Xhold1207 _4864_/Q VDD VSS _3522_/A sg13g2_dlygate4sd3_1
X_3293_ _4929_/Q _3293_/B _3293_/C _3293_/Y VDD VSS sg13g2_nor3_1
XFILLER_98_878 VDD VSS sg13g2_fill_2
Xhold1218 _4411_/Q VDD VSS _2984_/A0 sg13g2_dlygate4sd3_1
Xhold1229 _4813_/Q VDD VSS _3919_/A sg13g2_dlygate4sd3_1
X_2244_ VDD _2244_/Y _2476_/C VSS sg13g2_inv_1
XFILLER_97_399 VDD VSS sg13g2_decap_8
XFILLER_18_0 VDD VSS sg13g2_decap_8
XFILLER_65_252 VDD VSS sg13g2_fill_1
XFILLER_81_712 VDD VSS sg13g2_decap_8
XFILLER_81_723 VDD VSS sg13g2_fill_1
XFILLER_25_116 VDD VSS sg13g2_decap_8
XFILLER_25_149 VDD VSS sg13g2_fill_2
XFILLER_41_609 VDD VSS sg13g2_decap_4
XFILLER_80_244 VDD VSS sg13g2_decap_8
XFILLER_22_845 VDD VSS sg13g2_fill_2
XFILLER_34_694 VDD VSS sg13g2_fill_1
XFILLER_21_322 VDD VSS sg13g2_decap_8
XFILLER_22_856 VDD VSS sg13g2_decap_8
XFILLER_61_491 VDD VSS sg13g2_decap_8
X_4816_ fanout292/X VSS VDD _4816_/D _4816_/Q _4817_/CLK sg13g2_dfrbpq_1
XFILLER_31_49 VDD VSS sg13g2_decap_4
X_4747_ fanout273/X VSS VDD _4747_/D _4747_/Q _4749_/CLK sg13g2_dfrbpq_1
XFILLER_107_416 VDD VSS sg13g2_fill_1
X_4678_ fanout251/X VSS VDD _4678_/D _4678_/Q clkload4/A sg13g2_dfrbpq_1
X_3629_ VSS VDD _3700_/C _3635_/B _3688_/A sg13g2_or2_1
XFILLER_1_705 VDD VSS sg13g2_decap_8
Xoutput16 _2719_/Y ld5 VDD VSS sg13g2_buf_1
XFILLER_89_801 VDD VSS sg13g2_decap_8
XFILLER_89_845 VDD VSS sg13g2_decap_8
XFILLER_88_333 VDD VSS sg13g2_decap_8
XFILLER_0_259 VDD VSS sg13g2_decap_8
XFILLER_49_709 VDD VSS sg13g2_decap_8
XFILLER_76_506 VDD VSS sg13g2_decap_8
XFILLER_88_366 VDD VSS sg13g2_fill_1
XFILLER_88_344 VDD VSS sg13g2_fill_2
XFILLER_102_187 VDD VSS sg13g2_fill_1
XFILLER_29_444 VDD VSS sg13g2_decap_8
XFILLER_57_753 VDD VSS sg13g2_decap_4
XFILLER_69_591 VDD VSS sg13g2_decap_8
XFILLER_72_723 VDD VSS sg13g2_decap_8
XFILLER_84_561 VDD VSS sg13g2_decap_4
XFILLER_16_116 VDD VSS sg13g2_decap_8
XFILLER_72_23 VDD VSS sg13g2_fill_1
XFILLER_72_34 VDD VSS sg13g2_fill_1
XFILLER_31_119 VDD VSS sg13g2_decap_4
X_4267__459 VDD VSS _4267_/RESET_B sg13g2_tiehi
XFILLER_13_889 VDD VSS sg13g2_decap_8
XFILLER_40_675 VDD VSS sg13g2_fill_2
XFILLER_9_849 VDD VSS sg13g2_decap_8
XFILLER_8_315 VDD VSS sg13g2_fill_2
XFILLER_21_71 VDD VSS sg13g2_decap_8
XFILLER_4_565 VDD VSS sg13g2_fill_1
XFILLER_0_760 VDD VSS sg13g2_decap_8
XFILLER_67_539 VDD VSS sg13g2_decap_8
XFILLER_79_388 VDD VSS sg13g2_decap_8
XFILLER_79_399 VDD VSS sg13g2_fill_1
XFILLER_95_859 VDD VSS sg13g2_decap_8
XFILLER_11_7 VDD VSS sg13g2_decap_8
XFILLER_63_701 VDD VSS sg13g2_decap_8
XFILLER_62_200 VDD VSS sg13g2_decap_8
X_3980_ VSS VDD _3999_/A _3985_/A _3980_/Y _3979_/Y sg13g2_a21oi_1
X_2931_ _2931_/A0 _3086_/A0 _2955_/S _4361_/D VDD VSS sg13g2_mux2_1
Xclkbuf_0_clk clkbuf_0_clk/X clk VDD VSS sg13g2_buf_16
X_4601_ fanout289/X VSS VDD _4601_/D _4601_/Q _4601_/CLK sg13g2_dfrbpq_1
X_2862_ _2862_/A0 _3021_/A1 _2873_/S _2862_/X VDD VSS sg13g2_mux2_1
X_2793_ _2807_/A _2793_/B _2793_/C _4905_/D VDD VSS sg13g2_nor3_1
XFILLER_7_40 VDD VSS sg13g2_decap_8
X_4532_ fanout297/X VSS VDD _4532_/D _4532_/Q _4966_/CLK sg13g2_dfrbpq_1
XFILLER_116_235 VDD VSS sg13g2_decap_8
XFILLER_7_370 VDD VSS sg13g2_decap_8
X_4463_ fanout306/X VSS VDD _4463_/D _4463_/Q _4975_/CLK sg13g2_dfrbpq_1
X_3414_ _3413_/Y _3412_/Y _3339_/B _3420_/B VDD VSS sg13g2_a21o_1
XFILLER_89_119 VDD VSS sg13g2_decap_8
XFILLER_113_920 VDD VSS sg13g2_decap_4
X_4394_ _4394_/RESET_B VSS VDD _4394_/D _4394_/Q _4965_/CLK sg13g2_dfrbpq_1
XFILLER_98_620 VDD VSS sg13g2_decap_8
XFILLER_112_441 VDD VSS sg13g2_fill_1
X_3345_ VSS VDD _3394_/A _3469_/C _3345_/Y _3348_/A sg13g2_a21oi_1
XFILLER_58_539 VDD VSS sg13g2_fill_1
XFILLER_85_325 VDD VSS sg13g2_decap_8
Xhold1004 _3036_/X VDD VSS _4462_/D sg13g2_dlygate4sd3_1
Xhold1015 _4808_/Q VDD VSS _3905_/A sg13g2_dlygate4sd3_1
X_3276_ _3281_/A _3276_/B _4616_/D VDD VSS sg13g2_nor2_1
XFILLER_98_686 VDD VSS sg13g2_decap_8
XFILLER_86_848 VDD VSS sg13g2_decap_8
XFILLER_38_230 VDD VSS sg13g2_decap_8
Xhold1026 _2939_/X VDD VSS _4369_/D sg13g2_dlygate4sd3_1
Xhold1037 _3089_/X VDD VSS _4513_/D sg13g2_dlygate4sd3_1
Xhold1048 _4300_/Q VDD VSS _2865_/A0 sg13g2_dlygate4sd3_1
Xhold1059 _4397_/Q VDD VSS _2968_/A0 sg13g2_dlygate4sd3_1
XFILLER_94_870 VDD VSS sg13g2_decap_8
XFILLER_38_296 VDD VSS sg13g2_decap_8
XFILLER_54_756 VDD VSS sg13g2_fill_2
XFILLER_42_907 VDD VSS sg13g2_fill_1
XFILLER_13_119 VDD VSS sg13g2_decap_8
XFILLER_53_277 VDD VSS sg13g2_decap_8
XFILLER_22_675 VDD VSS sg13g2_decap_8
XFILLER_6_819 VDD VSS sg13g2_decap_8
XFILLER_107_246 VDD VSS sg13g2_decap_8
XFILLER_1_524 VDD VSS sg13g2_decap_8
Xhold882 _4417_/Q VDD VSS hold882/X sg13g2_dlygate4sd3_1
Xhold871 _2966_/X VDD VSS _4395_/D sg13g2_dlygate4sd3_1
Xhold860 _4371_/Q VDD VSS hold860/X sg13g2_dlygate4sd3_1
XFILLER_77_804 VDD VSS sg13g2_decap_8
Xhold893 _3808_/Y VDD VSS _4776_/D sg13g2_dlygate4sd3_1
XFILLER_1_579 VDD VSS sg13g2_fill_2
XFILLER_67_56 VDD VSS sg13g2_decap_8
XFILLER_88_163 VDD VSS sg13g2_decap_8
XFILLER_76_347 VDD VSS sg13g2_decap_4
XFILLER_57_550 VDD VSS sg13g2_decap_8
Xhold1560 _4775_/Q VDD VSS _3489_/A sg13g2_dlygate4sd3_1
Xhold1571 _3523_/A VDD VSS _3524_/A sg13g2_dlygate4sd3_1
XFILLER_29_296 VDD VSS sg13g2_decap_8
XFILLER_44_222 VDD VSS sg13g2_decap_8
XFILLER_45_723 VDD VSS sg13g2_decap_8
Xhold1582 _3154_/X VDD VSS _3155_/A2 sg13g2_dlygate4sd3_1
Xhold1593 _4628_/Q VDD VSS _3299_/A1 sg13g2_dlygate4sd3_1
XFILLER_91_328 VDD VSS sg13g2_fill_2
XFILLER_85_892 VDD VSS sg13g2_decap_8
XFILLER_13_620 VDD VSS sg13g2_decap_8
XFILLER_12_141 VDD VSS sg13g2_fill_2
XFILLER_12_152 VDD VSS sg13g2_decap_8
XFILLER_8_112 VDD VSS sg13g2_decap_8
XFILLER_13_697 VDD VSS sg13g2_decap_8
XFILLER_40_483 VDD VSS sg13g2_decap_8
XFILLER_32_70 VDD VSS sg13g2_decap_8
XFILLER_32_92 VDD VSS sg13g2_decap_8
XFILLER_5_830 VDD VSS sg13g2_decap_8
XFILLER_114_728 VDD VSS sg13g2_decap_8
XFILLER_59_7 VDD VSS sg13g2_decap_8
XFILLER_113_216 VDD VSS sg13g2_decap_8
XFILLER_113_227 VDD VSS sg13g2_fill_1
XFILLER_79_130 VDD VSS sg13g2_fill_2
XFILLER_79_141 VDD VSS sg13g2_decap_8
XFILLER_110_923 VDD VSS sg13g2_fill_2
XFILLER_67_314 VDD VSS sg13g2_fill_2
XFILLER_79_174 VDD VSS sg13g2_decap_8
X_3130_ _3130_/Y _3130_/A _3142_/B VDD VSS sg13g2_nand2_1
XFILLER_94_100 VDD VSS sg13g2_decap_4
X_3061_ _4035_/B _3061_/A1 _3084_/S _4487_/D VDD VSS sg13g2_mux2_1
XFILLER_35_222 VDD VSS sg13g2_fill_2
XFILLER_48_594 VDD VSS sg13g2_decap_8
XFILLER_90_361 VDD VSS sg13g2_decap_8
XFILLER_50_225 VDD VSS sg13g2_fill_1
X_3963_ _3962_/Y VDD _4825_/D VSS _4196_/A1 _4848_/D sg13g2_o21ai_1
XFILLER_85_0 VDD VSS sg13g2_decap_8
X_3894_ _3899_/C _3905_/A _3905_/D VDD VSS sg13g2_nand2_1
X_2914_ hold898/X _3096_/A0 _2922_/S _2914_/X VDD VSS sg13g2_mux2_1
XFILLER_31_494 VDD VSS sg13g2_decap_8
X_2845_ hold951/X _3107_/A0 _2848_/S _4282_/D VDD VSS sg13g2_mux2_1
X_4515_ fanout267/X VSS VDD _4515_/D _4515_/Q _4926_/CLK sg13g2_dfrbpq_1
X_2776_ VSS VDD _2774_/A _2774_/B _2776_/Y _2775_/Y sg13g2_a21oi_1
XFILLER_104_216 VDD VSS sg13g2_fill_1
X_4446_ _4446_/RESET_B VSS VDD _4446_/D _4446_/Q _4824_/CLK sg13g2_dfrbpq_1
X_4296__430 VDD VSS _4296_/RESET_B sg13g2_tiehi
XFILLER_59_804 VDD VSS sg13g2_decap_8
X_4377_ _4377_/RESET_B VSS VDD _4377_/D _4377_/Q _4958_/CLK sg13g2_dfrbpq_1
X_3328_ _3385_/A _3415_/A _3416_/A VDD VSS sg13g2_nor2_1
XFILLER_98_461 VDD VSS sg13g2_decap_8
XFILLER_86_612 VDD VSS sg13g2_decap_4
XFILLER_86_601 VDD VSS sg13g2_fill_2
XFILLER_85_177 VDD VSS sg13g2_fill_1
X_3259_ _3281_/A _3259_/B _4609_/D VDD VSS sg13g2_nor2_1
XFILLER_86_689 VDD VSS sg13g2_decap_8
XFILLER_26_211 VDD VSS sg13g2_decap_8
XFILLER_39_594 VDD VSS sg13g2_decap_8
XFILLER_54_553 VDD VSS sg13g2_fill_2
XFILLER_81_350 VDD VSS sg13g2_decap_4
XFILLER_53_14 VDD VSS sg13g2_decap_8
XFILLER_54_575 VDD VSS sg13g2_fill_1
XFILLER_81_383 VDD VSS sg13g2_decap_8
XFILLER_22_461 VDD VSS sg13g2_decap_8
XFILLER_6_627 VDD VSS sg13g2_decap_8
XFILLER_10_689 VDD VSS sg13g2_decap_4
XFILLER_5_115 VDD VSS sg13g2_decap_4
XFILLER_1_310 VDD VSS sg13g2_decap_8
XFILLER_2_855 VDD VSS sg13g2_decap_8
XFILLER_78_44 VDD VSS sg13g2_decap_8
Xhold690 _4885_/Q VDD VSS _2564_/A sg13g2_dlygate4sd3_1
XFILLER_103_260 VDD VSS sg13g2_decap_8
XFILLER_77_623 VDD VSS sg13g2_decap_8
XFILLER_1_387 VDD VSS sg13g2_decap_8
XFILLER_89_494 VDD VSS sg13g2_decap_8
XFILLER_94_21 VDD VSS sg13g2_decap_8
XFILLER_57_380 VDD VSS sg13g2_decap_8
XFILLER_76_199 VDD VSS sg13g2_fill_2
XFILLER_92_648 VDD VSS sg13g2_decap_8
XFILLER_17_233 VDD VSS sg13g2_decap_8
XFILLER_27_70 VDD VSS sg13g2_decap_8
XFILLER_45_542 VDD VSS sg13g2_decap_8
XFILLER_57_391 VDD VSS sg13g2_fill_1
Xhold1390 _4520_/Q VDD VSS hold1390/X sg13g2_dlygate4sd3_1
XFILLER_17_277 VDD VSS sg13g2_fill_1
XFILLER_32_203 VDD VSS sg13g2_decap_8
XFILLER_73_884 VDD VSS sg13g2_decap_8
XFILLER_41_770 VDD VSS sg13g2_decap_8
XFILLER_13_494 VDD VSS sg13g2_decap_8
XFILLER_40_280 VDD VSS sg13g2_decap_8
XFILLER_9_443 VDD VSS sg13g2_decap_8
X_2630_ _2630_/Y _3977_/S _3972_/D VDD VSS sg13g2_nand2_1
XFILLER_9_454 VDD VSS sg13g2_fill_1
XFILLER_9_487 VDD VSS sg13g2_decap_8
X_2561_ _2561_/B _2561_/C _2561_/A _2572_/A VDD VSS sg13g2_nand3_1
X_4300_ _4300_/RESET_B VSS VDD _4300_/D _4300_/Q _4397_/CLK sg13g2_dfrbpq_1
X_2492_ _3574_/A _2700_/A _3568_/A VDD VSS sg13g2_nand2_1
XFILLER_99_203 VDD VSS sg13g2_decap_4
XFILLER_114_547 VDD VSS sg13g2_decap_8
X_4231_ _4231_/A _4433_/Q _4231_/Y VDD VSS sg13g2_nor2_1
XFILLER_99_269 VDD VSS sg13g2_decap_4
XFILLER_4_63 VDD VSS sg13g2_decap_4
X_4162_ VSS VDD _4253_/A1 _4161_/X _4162_/Y _4218_/A1 sg13g2_a21oi_1
XFILLER_67_155 VDD VSS sg13g2_decap_8
X_4093_ VSS VDD _4196_/B1 _4092_/X _4093_/Y _2348_/Y sg13g2_a21oi_1
X_3113_ _4640_/Q hold904/X _3136_/B _3113_/X VDD VSS sg13g2_mux2_1
XFILLER_49_892 VDD VSS sg13g2_decap_8
XFILLER_82_103 VDD VSS sg13g2_decap_8
XFILLER_82_114 VDD VSS sg13g2_fill_2
X_3044_ _3531_/A1 _3070_/A _3051_/S _4470_/D VDD VSS sg13g2_mux2_1
XFILLER_24_704 VDD VSS sg13g2_fill_2
XFILLER_24_737 VDD VSS sg13g2_decap_8
XFILLER_36_586 VDD VSS sg13g2_decap_8
XFILLER_63_350 VDD VSS sg13g2_decap_4
XFILLER_23_236 VDD VSS sg13g2_decap_8
XFILLER_51_567 VDD VSS sg13g2_decap_8
X_3946_ _3954_/A VDD _3946_/Y VSS _3954_/C _3954_/D sg13g2_o21ai_1
XFILLER_31_291 VDD VSS sg13g2_decap_4
X_3877_ _3877_/A _3877_/B _3907_/B _3878_/B VDD VSS sg13g2_nor3_1
X_2828_ _2828_/A0 _3090_/A0 _2848_/S _2828_/X VDD VSS sg13g2_mux2_1
X_2759_ _2759_/A _2777_/A _2780_/B _2762_/B VDD VSS sg13g2_nor3_1
X_4429_ _4429_/RESET_B VSS VDD _4429_/D _4429_/Q _4817_/CLK sg13g2_dfrbpq_1
XFILLER_87_921 VDD VSS sg13g2_decap_4
XFILLER_86_431 VDD VSS sg13g2_decap_8
XFILLER_101_764 VDD VSS sg13g2_decap_8
XFILLER_58_199 VDD VSS sg13g2_decap_8
XFILLER_64_35 VDD VSS sg13g2_decap_8
XFILLER_73_158 VDD VSS sg13g2_fill_2
XFILLER_27_575 VDD VSS sg13g2_decap_8
XFILLER_70_810 VDD VSS sg13g2_decap_8
XFILLER_42_523 VDD VSS sg13g2_decap_4
XFILLER_54_383 VDD VSS sg13g2_decap_8
Xfanout40 _3879_/D _3905_/C VDD VSS sg13g2_buf_1
XFILLER_80_56 VDD VSS sg13g2_decap_8
Xfanout51 _3453_/C _3447_/C VDD VSS sg13g2_buf_1
Xfanout62 fanout67/X _3138_/B VDD VSS sg13g2_buf_1
Xfanout73 _3471_/B _3453_/B VDD VSS sg13g2_buf_1
XFILLER_10_453 VDD VSS sg13g2_decap_8
XFILLER_7_914 VDD VSS sg13g2_decap_8
XFILLER_7_925 VDD VSS sg13g2_fill_1
Xfanout84 fanout88/X _2979_/S VDD VSS sg13g2_buf_1
Xfanout95 fanout98/X _2927_/S VDD VSS sg13g2_buf_1
XFILLER_108_341 VDD VSS sg13g2_decap_4
XFILLER_89_43 VDD VSS sg13g2_decap_8
XFILLER_108_396 VDD VSS sg13g2_decap_8
XFILLER_2_630 VDD VSS sg13g2_fill_1
XFILLER_111_528 VDD VSS sg13g2_decap_8
XFILLER_96_206 VDD VSS sg13g2_decap_8
XFILLER_65_604 VDD VSS sg13g2_decap_8
XFILLER_65_615 VDD VSS sg13g2_fill_2
XFILLER_77_475 VDD VSS sg13g2_decap_8
XFILLER_93_924 VDD VSS sg13g2_fill_2
XFILLER_93_913 VDD VSS sg13g2_decap_8
XFILLER_49_199 VDD VSS sg13g2_decap_8
XFILLER_92_423 VDD VSS sg13g2_decap_8
XFILLER_46_862 VDD VSS sg13g2_decap_8
XFILLER_80_607 VDD VSS sg13g2_decap_8
XFILLER_18_564 VDD VSS sg13g2_decap_8
XFILLER_18_575 VDD VSS sg13g2_fill_2
XFILLER_45_361 VDD VSS sg13g2_fill_1
XFILLER_46_873 VDD VSS sg13g2_fill_2
XFILLER_45_383 VDD VSS sg13g2_decap_8
XFILLER_61_832 VDD VSS sg13g2_decap_8
X_4780_ fanout259/X VSS VDD _4780_/D _4780_/Q clkload0/A sg13g2_dfrbpq_1
X_4286__440 VDD VSS _4286_/RESET_B sg13g2_tiehi
X_3800_ _3800_/A _4768_/Q _3800_/C _3832_/B _3841_/B VDD VSS sg13g2_nor4_1
XFILLER_14_770 VDD VSS sg13g2_decap_8
X_3731_ _3731_/Y _3733_/B _3758_/B VDD VSS sg13g2_nand2_1
XFILLER_9_251 VDD VSS sg13g2_fill_1
Xclkload10 _4749_/CLK clkload10/X VDD VSS sg13g2_buf_8
X_3662_ _3686_/C _4730_/Q _3662_/X VDD VSS sg13g2_xor2_1
Xclkload21 VDD clkload21/Y _4968_/CLK VSS sg13g2_inv_1
Xclkload32 clkload32/Y _4972_/CLK VDD VSS sg13g2_inv_2
X_3593_ _3593_/A _3593_/B _3597_/B _3593_/Y VDD VSS sg13g2_nor3_1
X_2613_ _2613_/A _4614_/Q _3268_/B _2613_/Y VDD VSS sg13g2_nor3_1
X_2544_ _2546_/D _2543_/A _2543_/B _2544_/X VDD VSS sg13g2_a21o_1
XFILLER_115_856 VDD VSS sg13g2_decap_8
XFILLER_48_0 VDD VSS sg13g2_decap_8
XFILLER_114_366 VDD VSS sg13g2_decap_4
X_2475_ _3886_/B _2476_/A _3889_/C VDD VSS sg13g2_nand2_1
XFILLER_88_718 VDD VSS sg13g2_decap_8
XFILLER_87_217 VDD VSS sg13g2_decap_8
X_4293__433 VDD VSS _4293_/RESET_B sg13g2_tiehi
X_4214_ _4241_/B1 VDD _4214_/Y VSS _4241_/A1 _4456_/Q sg13g2_o21ai_1
XFILLER_96_740 VDD VSS sg13g2_fill_2
XFILLER_56_615 VDD VSS sg13g2_decap_8
XFILLER_84_913 VDD VSS sg13g2_decap_8
XFILLER_84_924 VDD VSS sg13g2_fill_2
X_4145_ _4245_/A1 VDD _4145_/Y VSS _4142_/Y _4143_/Y sg13g2_o21ai_1
XFILLER_18_28 VDD VSS sg13g2_decap_8
XFILLER_68_486 VDD VSS sg13g2_decap_8
XFILLER_83_412 VDD VSS sg13g2_decap_4
XFILLER_96_784 VDD VSS sg13g2_decap_8
XFILLER_95_261 VDD VSS sg13g2_decap_8
XFILLER_56_659 VDD VSS sg13g2_fill_2
XFILLER_83_467 VDD VSS sg13g2_fill_2
X_4076_ _2348_/A VDD _4076_/Y VSS _4074_/Y _4075_/Y sg13g2_o21ai_1
X_3027_ hold887/X _4527_/Q _3028_/S _3027_/X VDD VSS sg13g2_mux2_1
XFILLER_24_534 VDD VSS sg13g2_decap_8
XFILLER_70_128 VDD VSS sg13g2_fill_1
XFILLER_11_206 VDD VSS sg13g2_fill_2
XFILLER_11_228 VDD VSS sg13g2_decap_8
X_4978_ fanout307/X VSS VDD _4978_/D _4978_/Q _4978_/CLK sg13g2_dfrbpq_1
Xclkload4 clkload4/Y clkload4/A VDD VSS sg13g2_inv_2
X_3929_ _3929_/A _3929_/B _3930_/B VDD VSS sg13g2_nor2_1
XFILLER_109_127 VDD VSS sg13g2_decap_8
XFILLER_109_138 VDD VSS sg13g2_fill_2
XFILLER_106_867 VDD VSS sg13g2_decap_8
XFILLER_105_388 VDD VSS sg13g2_decap_4
XFILLER_59_431 VDD VSS sg13g2_fill_1
Xfanout230 hold845/X _3101_/A0 VDD VSS sg13g2_buf_1
Xfanout241 _4514_/Q _3090_/A0 VDD VSS sg13g2_buf_1
XFILLER_87_740 VDD VSS sg13g2_decap_8
XFILLER_115_52 VDD VSS sg13g2_decap_8
Xfanout252 fanout255/X fanout252/X VDD VSS sg13g2_buf_1
Xfanout263 fanout266/X fanout263/X VDD VSS sg13g2_buf_1
Xfanout274 fanout294/X fanout274/X VDD VSS sg13g2_buf_1
XFILLER_115_96 VDD VSS sg13g2_decap_8
XFILLER_19_306 VDD VSS sg13g2_decap_8
Xfanout285 fanout286/X fanout285/X VDD VSS sg13g2_buf_1
Xfanout296 fanout300/X fanout296/X VDD VSS sg13g2_buf_1
XFILLER_46_136 VDD VSS sg13g2_decap_8
XFILLER_28_873 VDD VSS sg13g2_decap_8
XFILLER_28_884 VDD VSS sg13g2_fill_1
XFILLER_46_169 VDD VSS sg13g2_decap_8
XFILLER_62_618 VDD VSS sg13g2_decap_8
XFILLER_15_578 VDD VSS sg13g2_decap_4
XFILLER_43_865 VDD VSS sg13g2_decap_8
XFILLER_54_191 VDD VSS sg13g2_decap_8
XFILLER_30_537 VDD VSS sg13g2_decap_8
XFILLER_42_397 VDD VSS sg13g2_decap_8
XFILLER_70_695 VDD VSS sg13g2_decap_8
XFILLER_24_71 VDD VSS sg13g2_decap_8
XFILLER_11_773 VDD VSS sg13g2_decap_8
XFILLER_109_650 VDD VSS sg13g2_fill_1
XFILLER_10_294 VDD VSS sg13g2_decap_8
XFILLER_7_755 VDD VSS sg13g2_decap_8
XFILLER_6_298 VDD VSS sg13g2_decap_8
XFILLER_111_303 VDD VSS sg13g2_decap_8
XFILLER_41_7 VDD VSS sg13g2_fill_1
XFILLER_69_228 VDD VSS sg13g2_decap_8
X_2260_ VDD _2260_/Y _2516_/C VSS sg13g2_inv_1
XFILLER_111_347 VDD VSS sg13g2_fill_2
XFILLER_77_250 VDD VSS sg13g2_decap_8
XFILLER_38_626 VDD VSS sg13g2_fill_2
XFILLER_65_423 VDD VSS sg13g2_decap_8
XFILLER_66_924 VDD VSS sg13g2_fill_2
XFILLER_78_795 VDD VSS sg13g2_decap_8
XFILLER_1_42 VDD VSS sg13g2_decap_8
XFILLER_1_86 VDD VSS sg13g2_decap_8
XFILLER_93_776 VDD VSS sg13g2_decap_8
XFILLER_80_437 VDD VSS sg13g2_decap_8
X_4901_ fanout246/X VSS VDD _4901_/D _4901_/Q clkload1/A sg13g2_dfrbpq_1
XFILLER_21_504 VDD VSS sg13g2_decap_8
XFILLER_33_353 VDD VSS sg13g2_decap_8
XFILLER_34_865 VDD VSS sg13g2_decap_8
XFILLER_34_876 VDD VSS sg13g2_fill_1
XFILLER_60_172 VDD VSS sg13g2_fill_1
X_4832_ fanout271/X VSS VDD _4832_/D _4832_/Q _4942_/CLK sg13g2_dfrbpq_1
X_4763_ fanout249/X VSS VDD _4763_/D _4763_/Q clkload1/A sg13g2_dfrbpq_1
X_4694_ fanout302/X VSS VDD _4694_/D _4694_/Q _4974_/CLK sg13g2_dfrbpq_1
X_3714_ _3714_/Y _3711_/Y _3713_/Y _3726_/B _3987_/B VDD VSS sg13g2_a22oi_1
X_3645_ _3645_/A0 _4639_/Q _3652_/S _3645_/X VDD VSS sg13g2_mux2_1
X_3576_ _3576_/A _3580_/B _3576_/C _4719_/D VDD VSS sg13g2_nor3_1
X_2527_ _4767_/Q _4766_/Q _2527_/X VDD VSS sg13g2_and2_1
XFILLER_88_515 VDD VSS sg13g2_fill_2
XFILLER_88_504 VDD VSS sg13g2_decap_8
XFILLER_102_314 VDD VSS sg13g2_decap_8
X_2458_ _2458_/A _4851_/Q _2458_/C _2458_/Y VDD VSS sg13g2_nor3_1
XFILLER_88_537 VDD VSS sg13g2_decap_8
XFILLER_111_881 VDD VSS sg13g2_fill_1
XFILLER_57_924 VDD VSS sg13g2_fill_2
X_2389_ _2389_/B _2389_/C _2389_/A _2389_/Y VDD VSS sg13g2_nand3_1
XFILLER_110_391 VDD VSS sg13g2_decap_8
XFILLER_29_659 VDD VSS sg13g2_decap_8
XFILLER_56_434 VDD VSS sg13g2_decap_8
XFILLER_68_294 VDD VSS sg13g2_decap_8
XFILLER_83_242 VDD VSS sg13g2_decap_8
X_4128_ VSS VDD _4244_/A1 _4126_/X _4128_/Y _4127_/Y sg13g2_a21oi_1
XFILLER_16_309 VDD VSS sg13g2_fill_1
XFILLER_28_169 VDD VSS sg13g2_decap_8
XFILLER_56_489 VDD VSS sg13g2_decap_8
X_4059_ _4038_/A _4266_/Q _4291_/Q _4316_/Q _4341_/Q _4172_/S1 _4059_/X VDD VSS sg13g2_mux4_1
XFILLER_25_821 VDD VSS sg13g2_fill_2
XFILLER_37_681 VDD VSS sg13g2_decap_8
XFILLER_37_692 VDD VSS sg13g2_fill_1
XFILLER_43_139 VDD VSS sg13g2_fill_2
XFILLER_101_21 VDD VSS sg13g2_decap_8
XFILLER_24_331 VDD VSS sg13g2_decap_8
XFILLER_52_640 VDD VSS sg13g2_decap_8
XFILLER_52_651 VDD VSS sg13g2_fill_2
XFILLER_101_54 VDD VSS sg13g2_decap_8
XFILLER_12_526 VDD VSS sg13g2_decap_4
XFILLER_61_14 VDD VSS sg13g2_decap_8
XFILLER_20_570 VDD VSS sg13g2_decap_8
XFILLER_4_725 VDD VSS sg13g2_decap_8
XFILLER_3_268 VDD VSS sg13g2_fill_1
XFILLER_79_548 VDD VSS sg13g2_decap_8
XFILLER_48_913 VDD VSS sg13g2_decap_8
X_4276__450 VDD VSS _4276_/RESET_B sg13g2_tiehi
XFILLER_86_33 VDD VSS sg13g2_decap_4
XFILLER_102_870 VDD VSS sg13g2_decap_4
XFILLER_47_401 VDD VSS sg13g2_decap_8
XFILLER_48_924 VDD VSS sg13g2_fill_2
XFILLER_94_529 VDD VSS sg13g2_fill_1
XFILLER_86_66 VDD VSS sg13g2_decap_8
XFILLER_19_71 VDD VSS sg13g2_decap_8
XFILLER_63_905 VDD VSS sg13g2_decap_4
XFILLER_19_158 VDD VSS sg13g2_decap_8
XFILLER_35_629 VDD VSS sg13g2_decap_8
XFILLER_47_467 VDD VSS sg13g2_decap_8
XFILLER_16_832 VDD VSS sg13g2_decap_8
XFILLER_62_437 VDD VSS sg13g2_decap_8
XFILLER_90_735 VDD VSS sg13g2_decap_8
XFILLER_15_342 VDD VSS sg13g2_decap_8
XFILLER_35_70 VDD VSS sg13g2_decap_8
XFILLER_43_651 VDD VSS sg13g2_decap_8
XFILLER_30_345 VDD VSS sg13g2_decap_8
XFILLER_31_846 VDD VSS sg13g2_decap_8
XFILLER_70_492 VDD VSS sg13g2_decap_8
XFILLER_89_7 VDD VSS sg13g2_fill_2
X_4283__443 VDD VSS _4283_/RESET_B sg13g2_tiehi
XFILLER_7_563 VDD VSS sg13g2_decap_8
X_3430_ _3429_/Y VDD _3430_/Y VSS _2264_/Y _3443_/C sg13g2_o21ai_1
XFILLER_112_601 VDD VSS sg13g2_fill_1
X_3361_ _3361_/B _3361_/A _3361_/X VDD VSS sg13g2_xor2_1
XFILLER_112_634 VDD VSS sg13g2_decap_8
X_2312_ VDD _3399_/A _2312_/A VSS sg13g2_inv_1
X_3292_ VSS VDD _2621_/A _3291_/Y _3293_/C _4623_/Q sg13g2_a21oi_1
XFILLER_111_177 VDD VSS sg13g2_fill_2
Xhold1208 _2699_/Y VDD VSS _4864_/D sg13g2_dlygate4sd3_1
Xhold1219 _4405_/Q VDD VSS _2976_/A0 sg13g2_dlygate4sd3_1
X_4290__436 VDD VSS _4290_/RESET_B sg13g2_tiehi
X_2243_ VDD _3901_/A _3891_/B VSS sg13g2_inv_1
XFILLER_97_378 VDD VSS sg13g2_decap_8
XFILLER_53_437 VDD VSS sg13g2_decap_8
XFILLER_80_201 VDD VSS sg13g2_fill_1
XFILLER_15_29 VDD VSS sg13g2_fill_1
XFILLER_80_267 VDD VSS sg13g2_fill_1
XFILLER_81_768 VDD VSS sg13g2_decap_8
XFILLER_21_301 VDD VSS sg13g2_decap_8
XFILLER_22_824 VDD VSS sg13g2_decap_8
X_4815_ fanout292/X VSS VDD _4815_/D _4815_/Q _4817_/CLK sg13g2_dfrbpq_1
XFILLER_31_28 VDD VSS sg13g2_decap_8
X_4746_ fanout273/X VSS VDD _4746_/D _4746_/Q _4749_/CLK sg13g2_dfrbpq_1
X_4677_ fanout251/X VSS VDD _4677_/D _4677_/Q clkload4/A sg13g2_dfrbpq_1
X_3628_ _3688_/A _3635_/B _3636_/C VDD VSS sg13g2_nor2_1
Xoutput17 _2717_/X ld6 VDD VSS sg13g2_buf_1
X_3559_ _3559_/Y _3563_/B _3601_/B VDD VSS sg13g2_nand2_1
XFILLER_0_238 VDD VSS sg13g2_decap_8
XFILLER_102_133 VDD VSS sg13g2_decap_4
XFILLER_103_656 VDD VSS sg13g2_decap_8
XFILLER_56_14 VDD VSS sg13g2_decap_8
XFILLER_69_570 VDD VSS sg13g2_fill_2
XFILLER_102_199 VDD VSS sg13g2_decap_8
XFILLER_56_25 VDD VSS sg13g2_fill_2
XFILLER_57_732 VDD VSS sg13g2_decap_8
XFILLER_84_540 VDD VSS sg13g2_decap_8
XFILLER_29_467 VDD VSS sg13g2_fill_1
XFILLER_45_916 VDD VSS sg13g2_decap_8
XFILLER_44_448 VDD VSS sg13g2_fill_2
XFILLER_71_267 VDD VSS sg13g2_decap_8
XFILLER_12_312 VDD VSS sg13g2_fill_2
XFILLER_13_824 VDD VSS sg13g2_fill_2
XFILLER_25_695 VDD VSS sg13g2_decap_8
XFILLER_12_323 VDD VSS sg13g2_fill_2
XFILLER_13_868 VDD VSS sg13g2_decap_8
XFILLER_115_0 VDD VSS sg13g2_decap_8
XFILLER_21_61 VDD VSS sg13g2_fill_1
XFILLER_4_588 VDD VSS sg13g2_fill_1
X_4458__468 VDD VSS _4458_/RESET_B sg13g2_tiehi
XFILLER_79_367 VDD VSS sg13g2_decap_8
XFILLER_97_87 VDD VSS sg13g2_decap_4
XFILLER_95_816 VDD VSS sg13g2_decap_8
XFILLER_95_838 VDD VSS sg13g2_decap_8
XFILLER_48_787 VDD VSS sg13g2_decap_8
XFILLER_47_286 VDD VSS sg13g2_decap_8
XFILLER_75_584 VDD VSS sg13g2_decap_4
XFILLER_35_459 VDD VSS sg13g2_decap_8
XFILLER_63_757 VDD VSS sg13g2_decap_8
XFILLER_22_109 VDD VSS sg13g2_decap_8
XFILLER_62_289 VDD VSS sg13g2_decap_8
X_2930_ _2983_/A _2956_/B _2930_/Y VDD VSS sg13g2_nor2_1
XFILLER_90_598 VDD VSS sg13g2_decap_8
XFILLER_15_183 VDD VSS sg13g2_decap_8
X_4600_ fanout289/X VSS VDD _4600_/D _4600_/Q _4601_/CLK sg13g2_dfrbpq_1
X_2861_ hold890/X _3096_/A0 _2869_/S _2861_/X VDD VSS sg13g2_mux2_1
XFILLER_30_175 VDD VSS sg13g2_decap_8
XFILLER_31_698 VDD VSS sg13g2_decap_8
X_2792_ _2792_/A _2792_/B _2793_/C VDD VSS sg13g2_nor2_1
X_4531_ fanout265/X VSS VDD _4531_/D _4531_/Q clkload8/A sg13g2_dfrbpq_1
XFILLER_8_883 VDD VSS sg13g2_decap_8
XFILLER_116_214 VDD VSS sg13g2_decap_8
XFILLER_7_96 VDD VSS sg13g2_decap_8
X_4462_ fanout307/X VSS VDD _4462_/D _4462_/Q _4975_/CLK sg13g2_dfrbpq_1
X_3413_ _4789_/Q _4786_/Q _3413_/C _3413_/D _3413_/Y VDD VSS sg13g2_nor4_1
X_4393_ _4393_/RESET_B VSS VDD _4393_/D _4393_/Q clkload6/A sg13g2_dfrbpq_1
XFILLER_30_0 VDD VSS sg13g2_decap_8
X_3344_ VSS VDD _3408_/A _3342_/Y _3344_/Y _3343_/Y sg13g2_a21oi_1
XFILLER_97_142 VDD VSS sg13g2_decap_4
XFILLER_85_315 VDD VSS sg13g2_fill_1
Xhold1005 _4470_/Q VDD VSS _3531_/A1 sg13g2_dlygate4sd3_1
X_3275_ _3275_/B _3275_/A _3275_/X VDD VSS sg13g2_xor2_1
XFILLER_39_754 VDD VSS sg13g2_decap_8
Xhold1016 _3896_/Y VDD VSS _3897_/B1 sg13g2_dlygate4sd3_1
Xhold1027 _4460_/Q VDD VSS _3034_/A0 sg13g2_dlygate4sd3_1
Xhold1038 _4370_/Q VDD VSS _2940_/A0 sg13g2_dlygate4sd3_1
Xhold1049 _2865_/X VDD VSS _4300_/D sg13g2_dlygate4sd3_1
XFILLER_39_798 VDD VSS sg13g2_decap_4
XFILLER_53_201 VDD VSS sg13g2_decap_8
XFILLER_81_521 VDD VSS sg13g2_decap_8
XFILLER_53_256 VDD VSS sg13g2_decap_8
XFILLER_34_470 VDD VSS sg13g2_decap_8
XFILLER_42_16 VDD VSS sg13g2_fill_1
XFILLER_22_654 VDD VSS sg13g2_decap_8
X_4266__460 VDD VSS _4266_/RESET_B sg13g2_tiehi
XFILLER_21_186 VDD VSS sg13g2_decap_8
XFILLER_108_715 VDD VSS sg13g2_decap_4
X_4729_ fanout324/X VSS VDD _4729_/D _4729_/Q _4729_/CLK sg13g2_dfrbpq_1
XFILLER_107_225 VDD VSS sg13g2_decap_8
XFILLER_108_759 VDD VSS sg13g2_decap_8
Xhold872 _4547_/Q VDD VSS hold872/X sg13g2_dlygate4sd3_1
Xhold861 _2941_/X VDD VSS _4371_/D sg13g2_dlygate4sd3_1
Xhold850 _3038_/X VDD VSS _4464_/D sg13g2_dlygate4sd3_1
XFILLER_107_64 VDD VSS sg13g2_decap_8
Xhold894 _4484_/Q VDD VSS hold894/X sg13g2_dlygate4sd3_1
Xhold883 _4435_/Q VDD VSS hold883/X sg13g2_dlygate4sd3_1
XFILLER_103_464 VDD VSS sg13g2_fill_1
XFILLER_49_507 VDD VSS sg13g2_decap_8
XFILLER_67_35 VDD VSS sg13g2_decap_8
XFILLER_89_698 VDD VSS sg13g2_fill_2
XFILLER_89_687 VDD VSS sg13g2_decap_8
XFILLER_103_497 VDD VSS sg13g2_fill_2
XFILLER_76_326 VDD VSS sg13g2_decap_8
X_4273__453 VDD VSS _4273_/RESET_B sg13g2_tiehi
XFILLER_88_186 VDD VSS sg13g2_decap_8
Xhold1550 _4920_/Q VDD VSS _2420_/A sg13g2_dlygate4sd3_1
Xhold1561 _4948_/Q VDD VSS _2739_/A sg13g2_dlygate4sd3_1
XFILLER_91_307 VDD VSS sg13g2_decap_8
XFILLER_85_871 VDD VSS sg13g2_decap_8
XFILLER_17_426 VDD VSS sg13g2_decap_4
XFILLER_29_275 VDD VSS sg13g2_decap_8
XFILLER_44_201 VDD VSS sg13g2_decap_8
XFILLER_84_381 VDD VSS sg13g2_decap_8
Xhold1572 _4569_/Q VDD VSS _2259_/A sg13g2_dlygate4sd3_1
Xhold1583 _3155_/Y VDD VSS _4564_/D sg13g2_dlygate4sd3_1
Xhold1594 _4561_/Q VDD VSS _3147_/B sg13g2_dlygate4sd3_1
XFILLER_83_67 VDD VSS sg13g2_decap_8
XFILLER_83_78 VDD VSS sg13g2_fill_1
XFILLER_16_94 VDD VSS sg13g2_decap_8
XFILLER_12_131 VDD VSS sg13g2_fill_1
XFILLER_13_676 VDD VSS sg13g2_decap_8
XFILLER_40_462 VDD VSS sg13g2_decap_8
XFILLER_12_186 VDD VSS sg13g2_decap_8
X_4280__446 VDD VSS _4280_/RESET_B sg13g2_tiehi
XFILLER_8_157 VDD VSS sg13g2_decap_8
XFILLER_5_886 VDD VSS sg13g2_decap_8
X_3060_ _4026_/B hold889/X _3084_/S _4486_/D VDD VSS sg13g2_mux2_1
XFILLER_95_657 VDD VSS sg13g2_fill_1
XFILLER_82_318 VDD VSS sg13g2_decap_8
XFILLER_36_746 VDD VSS sg13g2_decap_8
XFILLER_48_573 VDD VSS sg13g2_decap_8
XFILLER_24_908 VDD VSS sg13g2_decap_8
XFILLER_35_234 VDD VSS sg13g2_decap_8
XFILLER_63_565 VDD VSS sg13g2_fill_2
XFILLER_23_429 VDD VSS sg13g2_fill_2
XFILLER_50_204 VDD VSS sg13g2_decap_8
XFILLER_51_738 VDD VSS sg13g2_decap_8
XFILLER_63_587 VDD VSS sg13g2_decap_8
XFILLER_44_790 VDD VSS sg13g2_decap_8
X_3962_ _3962_/Y input5/X _4848_/D VDD VSS sg13g2_nand2_1
X_3893_ _3901_/A _3901_/C _3905_/D VDD VSS sg13g2_nor2_1
X_2913_ _2913_/A0 _3095_/A0 _2922_/S _2913_/X VDD VSS sg13g2_mux2_1
XFILLER_31_484 VDD VSS sg13g2_fill_1
X_2844_ _2844_/A0 _3106_/A0 _2848_/S _4281_/D VDD VSS sg13g2_mux2_1
XFILLER_78_0 VDD VSS sg13g2_decap_8
X_4514_ fanout284/X VSS VDD _4514_/D _4514_/Q _4559_/CLK sg13g2_dfrbpq_1
X_2775_ hold564/X VDD _2775_/Y VSS _2774_/A _2774_/B sg13g2_o21ai_1
X_4445_ _4445_/RESET_B VSS VDD _4445_/D _4445_/Q _4964_/CLK sg13g2_dfrbpq_1
XFILLER_104_239 VDD VSS sg13g2_decap_8
X_4376_ _4376_/RESET_B VSS VDD _4376_/D _4376_/Q _4972_/CLK sg13g2_dfrbpq_1
XFILLER_98_440 VDD VSS sg13g2_decap_8
XFILLER_101_913 VDD VSS sg13g2_decap_8
XFILLER_101_924 VDD VSS sg13g2_fill_2
XFILLER_59_838 VDD VSS sg13g2_fill_1
X_3327_ _3393_/C _3327_/A _3327_/B VDD VSS sg13g2_nand2_1
XFILLER_59_849 VDD VSS sg13g2_fill_2
XFILLER_37_49 VDD VSS sg13g2_decap_8
XFILLER_73_307 VDD VSS sg13g2_decap_8
X_3258_ _3258_/B _3258_/A _3258_/X VDD VSS sg13g2_xor2_1
XFILLER_100_489 VDD VSS sg13g2_decap_8
XFILLER_66_381 VDD VSS sg13g2_decap_4
XFILLER_73_318 VDD VSS sg13g2_fill_2
XFILLER_85_189 VDD VSS sg13g2_decap_8
X_3189_ _3189_/A _3189_/B _3189_/Y VDD VSS sg13g2_nor2_1
XFILLER_15_908 VDD VSS sg13g2_decap_8
XFILLER_54_532 VDD VSS sg13g2_decap_8
XFILLER_14_418 VDD VSS sg13g2_decap_8
XFILLER_26_289 VDD VSS sg13g2_fill_1
XFILLER_41_215 VDD VSS sg13g2_decap_4
XFILLER_42_727 VDD VSS sg13g2_decap_8
XFILLER_82_885 VDD VSS sg13g2_fill_2
XFILLER_82_896 VDD VSS sg13g2_fill_1
X_4448__478 VDD VSS _4448_/RESET_B sg13g2_tiehi
XFILLER_50_793 VDD VSS sg13g2_fill_2
XFILLER_10_679 VDD VSS sg13g2_fill_1
XFILLER_108_567 VDD VSS sg13g2_decap_8
XFILLER_5_149 VDD VSS sg13g2_decap_8
XFILLER_2_834 VDD VSS sg13g2_decap_8
Xhold680 _4937_/Q VDD VSS _2771_/B sg13g2_dlygate4sd3_1
XFILLER_1_366 VDD VSS sg13g2_decap_8
XFILLER_77_602 VDD VSS sg13g2_decap_8
Xhold691 _4910_/Q VDD VSS _2406_/B sg13g2_dlygate4sd3_1
XFILLER_76_101 VDD VSS sg13g2_decap_4
XFILLER_17_212 VDD VSS sg13g2_decap_8
XFILLER_18_735 VDD VSS sg13g2_fill_1
XFILLER_45_510 VDD VSS sg13g2_decap_4
XFILLER_45_521 VDD VSS sg13g2_decap_8
XFILLER_76_178 VDD VSS sg13g2_decap_8
XFILLER_92_627 VDD VSS sg13g2_decap_8
XFILLER_73_863 VDD VSS sg13g2_decap_8
Xhold1380 _4670_/Q VDD VSS _3463_/A sg13g2_dlygate4sd3_1
Xhold1391 _4945_/Q VDD VSS _2727_/A sg13g2_dlygate4sd3_1
XFILLER_45_587 VDD VSS sg13g2_decap_8
XFILLER_60_502 VDD VSS sg13g2_decap_4
XFILLER_60_568 VDD VSS sg13g2_fill_1
XFILLER_13_473 VDD VSS sg13g2_decap_8
XFILLER_9_422 VDD VSS sg13g2_decap_8
XFILLER_71_7 VDD VSS sg13g2_decap_8
XFILLER_9_466 VDD VSS sg13g2_decap_8
XFILLER_5_650 VDD VSS sg13g2_fill_2
X_2560_ VSS VDD _4883_/Q _2561_/C _2560_/Y _2561_/B sg13g2_a21oi_1
XFILLER_5_672 VDD VSS sg13g2_decap_8
X_2491_ _4717_/Q _3563_/B _4718_/Q _4719_/Q _3587_/D VDD VSS sg13g2_and4_1
XFILLER_4_42 VDD VSS sg13g2_decap_8
X_4230_ _4233_/S _4283_/Q _4308_/Q _4333_/Q _4358_/Q _2347_/A _4230_/X VDD VSS sg13g2_mux4_1
XFILLER_99_248 VDD VSS sg13g2_decap_8
XFILLER_68_602 VDD VSS sg13g2_decap_8
X_4161_ _4276_/Q _4301_/Q _4186_/S _4161_/X VDD VSS sg13g2_mux2_1
XFILLER_67_112 VDD VSS sg13g2_decap_8
XFILLER_68_646 VDD VSS sg13g2_decap_8
XFILLER_95_421 VDD VSS sg13g2_decap_8
XFILLER_110_754 VDD VSS sg13g2_decap_4
X_4092_ _4419_/Q _4444_/Q _4118_/S _4092_/X VDD VSS sg13g2_mux2_1
X_3112_ _4639_/Q hold841/X _3136_/B _3112_/X VDD VSS sg13g2_mux2_1
XFILLER_110_798 VDD VSS sg13g2_decap_8
XFILLER_49_871 VDD VSS sg13g2_decap_8
XFILLER_83_649 VDD VSS sg13g2_decap_8
X_3043_ hold906/X _3069_/A1 _3051_/S _4469_/D VDD VSS sg13g2_mux2_1
XFILLER_95_487 VDD VSS sg13g2_fill_1
XFILLER_36_532 VDD VSS sg13g2_fill_2
XFILLER_48_392 VDD VSS sg13g2_decap_8
XFILLER_64_852 VDD VSS sg13g2_decap_8
XFILLER_36_565 VDD VSS sg13g2_decap_8
XFILLER_23_215 VDD VSS sg13g2_decap_8
XFILLER_51_546 VDD VSS sg13g2_decap_8
X_3945_ VSS VDD _3952_/B1 _3944_/Y _3947_/A _3930_/A sg13g2_a21oi_1
X_3876_ VSS VDD _3879_/D _3873_/Y _3878_/A _2240_/Y sg13g2_a21oi_1
X_4263__463 VDD VSS _4263_/RESET_B sg13g2_tiehi
X_2827_ _2827_/A0 _3089_/A0 _2846_/S _2827_/X VDD VSS sg13g2_mux2_1
XFILLER_3_609 VDD VSS sg13g2_decap_8
X_2758_ _4903_/D _3788_/B _4904_/D VDD VSS sg13g2_nor2_1
X_4428_ _4428_/RESET_B VSS VDD _4428_/D _4428_/Q _4972_/CLK sg13g2_dfrbpq_1
X_2689_ _4729_/Q _2692_/B _2689_/C _2689_/D _2708_/B VDD VSS sg13g2_or4_1
XFILLER_101_743 VDD VSS sg13g2_decap_8
X_4359_ _4359_/RESET_B VSS VDD _4359_/D _4359_/Q _4971_/CLK sg13g2_dfrbpq_1
XFILLER_100_253 VDD VSS sg13g2_decap_8
XFILLER_48_59 VDD VSS sg13g2_decap_8
XFILLER_58_145 VDD VSS sg13g2_fill_2
XFILLER_100_264 VDD VSS sg13g2_fill_1
XFILLER_86_487 VDD VSS sg13g2_decap_8
XFILLER_55_830 VDD VSS sg13g2_decap_8
XFILLER_55_841 VDD VSS sg13g2_fill_1
XFILLER_64_14 VDD VSS sg13g2_decap_8
X_4270__456 VDD VSS _4270_/RESET_B sg13g2_tiehi
XFILLER_27_565 VDD VSS sg13g2_decap_4
XFILLER_42_502 VDD VSS sg13g2_decap_8
XFILLER_54_362 VDD VSS sg13g2_decap_4
XFILLER_55_896 VDD VSS sg13g2_decap_8
Xfanout30 _2604_/A _3193_/B VDD VSS sg13g2_buf_1
XFILLER_11_922 VDD VSS sg13g2_decap_4
XFILLER_70_899 VDD VSS sg13g2_decap_8
XFILLER_80_35 VDD VSS sg13g2_decap_8
Xfanout41 _3939_/C _3879_/D VDD VSS sg13g2_buf_1
Xfanout52 _3444_/A2 _3453_/C VDD VSS sg13g2_buf_1
Xfanout63 fanout67/X _3140_/B VDD VSS sg13g2_buf_1
Xfanout74 _3306_/X _3471_/B VDD VSS sg13g2_buf_1
Xfanout85 fanout88/X _2980_/S VDD VSS sg13g2_buf_1
Xfanout96 fanout98/X _2928_/S VDD VSS sg13g2_buf_1
XFILLER_6_425 VDD VSS sg13g2_decap_8
XFILLER_108_320 VDD VSS sg13g2_decap_8
XFILLER_13_95 VDD VSS sg13g2_decap_4
XFILLER_108_375 VDD VSS sg13g2_decap_8
X_4379__347 VDD VSS _4379_/RESET_B sg13g2_tiehi
XFILLER_89_66 VDD VSS sg13g2_decap_8
XFILLER_8_0 VDD VSS sg13g2_fill_1
XFILLER_1_185 VDD VSS sg13g2_decap_4
XFILLER_29_9 VDD VSS sg13g2_fill_1
XFILLER_49_123 VDD VSS sg13g2_decap_8
XFILLER_77_454 VDD VSS sg13g2_decap_8
XFILLER_49_178 VDD VSS sg13g2_decap_8
XFILLER_64_115 VDD VSS sg13g2_decap_8
XFILLER_77_498 VDD VSS sg13g2_fill_1
XFILLER_18_521 VDD VSS sg13g2_fill_2
XFILLER_64_148 VDD VSS sg13g2_fill_2
XFILLER_64_159 VDD VSS sg13g2_decap_8
XFILLER_46_885 VDD VSS sg13g2_fill_1
XFILLER_61_800 VDD VSS sg13g2_decap_4
XFILLER_60_321 VDD VSS sg13g2_decap_8
XFILLER_60_332 VDD VSS sg13g2_fill_2
X_3730_ _3729_/Y VDD _4757_/D VSS _3792_/B _3766_/A1 sg13g2_o21ai_1
XFILLER_41_590 VDD VSS sg13g2_decap_8
X_3661_ _4733_/Q VDD _3686_/C VSS _4732_/Q _4731_/Q sg13g2_o21ai_1
XFILLER_9_263 VDD VSS sg13g2_decap_8
Xclkload11 clkload11/Y _4745_/CLK VDD VSS sg13g2_inv_2
Xclkload22 clkload22/Y _4967_/CLK VDD VSS sg13g2_inv_2
Xclkload33 VDD clkload33/Y _4961_/CLK VSS sg13g2_inv_1
X_3592_ _3597_/B _3602_/A _3592_/B _3603_/D VDD VSS sg13g2_and3_1
X_2612_ _3268_/B _2615_/A _2615_/C VDD VSS sg13g2_nand2_1
XFILLER_115_835 VDD VSS sg13g2_decap_8
X_2543_ _2543_/B _2546_/D _2543_/A _2547_/B VDD VSS sg13g2_nand3_1
XFILLER_114_323 VDD VSS sg13g2_decap_8
XFILLER_114_334 VDD VSS sg13g2_fill_1
XFILLER_102_507 VDD VSS sg13g2_fill_2
XFILLER_69_900 VDD VSS sg13g2_fill_2
XFILLER_69_911 VDD VSS sg13g2_decap_8
X_2474_ _4800_/Q _4801_/Q _4802_/Q _2474_/D _3889_/C VDD VSS sg13g2_and4_1
XFILLER_68_432 VDD VSS sg13g2_decap_8
X_4438__488 VDD VSS _4438_/RESET_B sg13g2_tiehi
X_4213_ _4240_/A _4431_/Q _4213_/Y VDD VSS sg13g2_nor2_1
XFILLER_110_551 VDD VSS sg13g2_fill_2
XFILLER_29_819 VDD VSS sg13g2_decap_8
X_4144_ hold936/X _4144_/A1 _4144_/S _4144_/X VDD VSS sg13g2_mux2_1
XFILLER_95_240 VDD VSS sg13g2_decap_8
XFILLER_28_307 VDD VSS sg13g2_decap_8
X_4075_ _4199_/A1 VDD _4075_/Y VSS _4250_/A1 _4392_/Q sg13g2_o21ai_1
XFILLER_83_479 VDD VSS sg13g2_decap_8
X_3026_ _4174_/A2 _3026_/A1 _3029_/S _3026_/X VDD VSS sg13g2_mux2_1
XFILLER_24_513 VDD VSS sg13g2_decap_8
XFILLER_52_855 VDD VSS sg13g2_fill_1
XFILLER_64_693 VDD VSS sg13g2_decap_8
XFILLER_91_490 VDD VSS sg13g2_decap_8
XFILLER_52_866 VDD VSS sg13g2_decap_4
X_4977_ fanout301/X VSS VDD _4977_/D _4977_/Q _4977_/CLK sg13g2_dfrbpq_1
Xclkload5 VDD clkload5/Y clkload5/A VSS sg13g2_inv_1
X_3928_ _3928_/A _3936_/A _3936_/B _3929_/B VDD VSS sg13g2_nor3_1
XFILLER_109_106 VDD VSS sg13g2_decap_8
XFILLER_50_49 VDD VSS sg13g2_decap_8
X_3859_ hold941/X hold927/X _4856_/D _4796_/D VDD VSS sg13g2_mux2_1
XFILLER_20_796 VDD VSS sg13g2_decap_8
XFILLER_4_907 VDD VSS sg13g2_decap_8
XFILLER_3_417 VDD VSS sg13g2_decap_8
XFILLER_105_312 VDD VSS sg13g2_decap_8
XFILLER_106_846 VDD VSS sg13g2_decap_8
XFILLER_59_14 VDD VSS sg13g2_decap_8
XFILLER_1_7 VDD VSS sg13g2_decap_8
XFILLER_78_229 VDD VSS sg13g2_decap_8
Xfanout220 hold1652/X _3868_/A VDD VSS sg13g2_buf_1
Xfanout231 hold1303/X _3100_/A0 VDD VSS sg13g2_buf_1
XFILLER_59_443 VDD VSS sg13g2_fill_2
Xfanout242 _4513_/Q _3089_/A0 VDD VSS sg13g2_buf_1
Xfanout253 fanout255/X fanout253/X VDD VSS sg13g2_buf_1
Xfanout264 fanout266/X fanout264/X VDD VSS sg13g2_buf_1
XFILLER_101_562 VDD VSS sg13g2_fill_2
XFILLER_46_115 VDD VSS sg13g2_decap_8
XFILLER_59_498 VDD VSS sg13g2_decap_8
Xfanout275 fanout278/X fanout275/X VDD VSS sg13g2_buf_1
Xfanout286 fanout287/X fanout286/X VDD VSS sg13g2_buf_1
Xfanout297 fanout300/X fanout297/X VDD VSS sg13g2_buf_1
XFILLER_101_595 VDD VSS sg13g2_fill_1
XFILLER_28_852 VDD VSS sg13g2_decap_8
XFILLER_27_351 VDD VSS sg13g2_fill_2
XFILLER_27_373 VDD VSS sg13g2_decap_4
XFILLER_43_844 VDD VSS sg13g2_decap_8
XFILLER_54_170 VDD VSS sg13g2_decap_8
XFILLER_15_557 VDD VSS sg13g2_decap_8
XFILLER_42_354 VDD VSS sg13g2_fill_1
XFILLER_70_663 VDD VSS sg13g2_decap_8
XFILLER_91_56 VDD VSS sg13g2_decap_8
XFILLER_30_516 VDD VSS sg13g2_decap_8
XFILLER_70_674 VDD VSS sg13g2_decap_8
XFILLER_11_752 VDD VSS sg13g2_decap_8
XFILLER_10_273 VDD VSS sg13g2_decap_8
XFILLER_6_233 VDD VSS sg13g2_decap_8
XFILLER_40_71 VDD VSS sg13g2_fill_1
XFILLER_6_277 VDD VSS sg13g2_decap_8
XFILLER_108_183 VDD VSS sg13g2_fill_1
XFILLER_112_805 VDD VSS sg13g2_decap_8
XFILLER_69_207 VDD VSS sg13g2_decap_8
XFILLER_2_472 VDD VSS sg13g2_decap_8
XFILLER_34_7 VDD VSS sg13g2_fill_1
XFILLER_78_741 VDD VSS sg13g2_decap_8
XFILLER_1_21 VDD VSS sg13g2_decap_8
XFILLER_93_755 VDD VSS sg13g2_decap_8
XFILLER_46_671 VDD VSS sg13g2_decap_8
XFILLER_80_405 VDD VSS sg13g2_fill_2
XFILLER_80_416 VDD VSS sg13g2_decap_8
XFILLER_34_822 VDD VSS sg13g2_fill_2
X_4900_ fanout246/X VSS VDD _4900_/D _4900_/Q _4904_/CLK sg13g2_dfrbpq_1
XFILLER_33_332 VDD VSS sg13g2_decap_8
XFILLER_61_652 VDD VSS sg13g2_decap_4
X_4831_ fanout271/X VSS VDD _4831_/D _4831_/Q _4942_/CLK sg13g2_dfrbpq_1
XFILLER_60_151 VDD VSS sg13g2_decap_8
XFILLER_61_696 VDD VSS sg13g2_decap_8
X_4762_ fanout249/X VSS VDD _4762_/D _4762_/Q clkload0/A sg13g2_dfrbpq_1
X_4693_ fanout325/X VSS VDD _4693_/D _4693_/Q _4868_/CLK sg13g2_dfrbpq_1
X_3713_ VSS VDD _2448_/B _3712_/Y _3713_/Y _3691_/Y sg13g2_a21oi_1
X_3644_ VSS VDD _3636_/A _3642_/B _3644_/Y _3643_/X sg13g2_a21oi_1
XFILLER_60_0 VDD VSS sg13g2_decap_8
X_3575_ VSS VDD _3568_/A _3592_/B _3575_/Y _2700_/A sg13g2_a21oi_1
X_2526_ VSS VDD _2295_/Y _3746_/A _2526_/Y _3826_/A sg13g2_a21oi_1
XFILLER_115_687 VDD VSS sg13g2_decap_4
X_2457_ VSS VDD _2238_/Y _4931_/D _2458_/C _4844_/Q sg13g2_a21oi_1
XFILLER_29_39 VDD VSS sg13g2_decap_8
XFILLER_29_638 VDD VSS sg13g2_decap_8
XFILLER_68_273 VDD VSS sg13g2_decap_8
X_2388_ _2388_/A _2388_/B _2388_/C _2388_/D _2389_/C VDD VSS sg13g2_nor4_1
XFILLER_110_370 VDD VSS sg13g2_decap_8
XFILLER_28_148 VDD VSS sg13g2_fill_2
XFILLER_83_210 VDD VSS sg13g2_decap_8
XFILLER_83_221 VDD VSS sg13g2_fill_2
XFILLER_83_232 VDD VSS sg13g2_decap_4
X_4127_ _4236_/A1 VDD _4127_/Y VSS _4124_/Y _4125_/Y sg13g2_o21ai_1
XFILLER_25_800 VDD VSS sg13g2_decap_8
XFILLER_37_660 VDD VSS sg13g2_decap_8
X_4058_ _4057_/Y VDD _4959_/D VSS _4055_/Y _4056_/Y sg13g2_o21ai_1
XFILLER_43_118 VDD VSS sg13g2_decap_8
XFILLER_43_129 VDD VSS sg13g2_fill_2
X_3009_ _3009_/A _3009_/B _3009_/Y VDD VSS sg13g2_nor2_1
XFILLER_52_663 VDD VSS sg13g2_fill_1
Xclkbuf_leaf_63_clk clkbuf_4_0_0_clk/X clkload1/A VDD VSS sg13g2_buf_8
X_4369__357 VDD VSS _4369_/RESET_B sg13g2_tiehi
XFILLER_51_140 VDD VSS sg13g2_decap_8
XFILLER_4_704 VDD VSS sg13g2_decap_8
XFILLER_106_643 VDD VSS sg13g2_fill_2
XFILLER_10_63 VDD VSS sg13g2_decap_8
XFILLER_0_921 VDD VSS sg13g2_decap_4
XFILLER_10_85 VDD VSS sg13g2_decap_8
XFILLER_79_527 VDD VSS sg13g2_decap_8
XFILLER_59_251 VDD VSS sg13g2_decap_8
XFILLER_47_446 VDD VSS sg13g2_decap_8
XFILLER_75_733 VDD VSS sg13g2_decap_8
XFILLER_35_608 VDD VSS sg13g2_decap_8
XFILLER_16_811 VDD VSS sg13g2_decap_8
XFILLER_62_416 VDD VSS sg13g2_decap_8
XFILLER_74_276 VDD VSS sg13g2_fill_2
XFILLER_43_630 VDD VSS sg13g2_decap_8
XFILLER_55_490 VDD VSS sg13g2_decap_8
Xclkbuf_leaf_54_clk clkbuf_4_9_0_clk/X _4971_/CLK VDD VSS sg13g2_buf_8
XFILLER_15_387 VDD VSS sg13g2_decap_8
XFILLER_30_302 VDD VSS sg13g2_fill_2
XFILLER_35_93 VDD VSS sg13g2_decap_8
XFILLER_70_471 VDD VSS sg13g2_decap_8
XFILLER_30_324 VDD VSS sg13g2_decap_8
X_4428__498 VDD VSS _4428_/RESET_B sg13g2_tiehi
XFILLER_11_593 VDD VSS sg13g2_decap_8
XFILLER_7_542 VDD VSS sg13g2_decap_8
XFILLER_116_429 VDD VSS sg13g2_decap_8
XFILLER_51_92 VDD VSS sg13g2_decap_8
X_3360_ _3360_/B _3360_/C _3360_/Y VDD VSS _4638_/Q sg13g2_nand3b_1
X_2311_ VDD _3405_/A _2311_/A VSS sg13g2_inv_1
X_3291_ _4895_/Q input2/X _3291_/Y VDD VSS sg13g2_nor2b_1
XFILLER_100_819 VDD VSS sg13g2_decap_8
XFILLER_111_156 VDD VSS sg13g2_decap_8
XFILLER_78_582 VDD VSS sg13g2_decap_8
Xhold1209 _4352_/Q VDD VSS _2920_/A0 sg13g2_dlygate4sd3_1
X_2242_ VDD _2242_/Y _3886_/A VSS sg13g2_inv_1
XFILLER_54_917 VDD VSS sg13g2_decap_8
XFILLER_65_243 VDD VSS sg13g2_decap_8
XFILLER_53_416 VDD VSS sg13g2_decap_8
XFILLER_34_630 VDD VSS sg13g2_fill_1
Xclkbuf_leaf_45_clk clkbuf_4_11_0_clk/X _4978_/CLK VDD VSS sg13g2_buf_8
XFILLER_34_663 VDD VSS sg13g2_decap_8
XFILLER_33_184 VDD VSS sg13g2_decap_8
X_4814_ fanout292/X VSS VDD _4814_/D _4814_/Q _4817_/CLK sg13g2_dfrbpq_1
X_4745_ fanout268/X VSS VDD _4745_/D _4745_/Q _4745_/CLK sg13g2_dfrbpq_1
X_4676_ fanout251/X VSS VDD _4676_/D _4676_/Q clkload4/A sg13g2_dfrbpq_1
X_3627_ _3627_/Y _3627_/A _3636_/B VDD VSS sg13g2_nand2_1
Xoutput18 _4894_/Q ld7 VDD VSS sg13g2_buf_1
X_3558_ VSS VDD _3592_/B _3558_/B _3558_/A sg13g2_or2_1
XFILLER_0_217 VDD VSS sg13g2_decap_8
XFILLER_115_495 VDD VSS sg13g2_decap_8
X_2509_ _3169_/B _3167_/B _3167_/A VDD VSS sg13g2_nand2b_1
XFILLER_102_112 VDD VSS sg13g2_decap_8
X_3489_ _3489_/A _3489_/B _3489_/C _3489_/D _3489_/X VDD VSS sg13g2_and4_1
XFILLER_102_178 VDD VSS sg13g2_decap_8
XFILLER_57_711 VDD VSS sg13g2_decap_8
XFILLER_29_413 VDD VSS sg13g2_decap_8
XFILLER_56_37 VDD VSS sg13g2_fill_2
XFILLER_112_21 VDD VSS sg13g2_decap_8
XFILLER_112_32 VDD VSS sg13g2_fill_1
XFILLER_56_287 VDD VSS sg13g2_decap_8
XFILLER_84_596 VDD VSS sg13g2_decap_8
XFILLER_71_235 VDD VSS sg13g2_decap_8
XFILLER_71_246 VDD VSS sg13g2_fill_1
XFILLER_72_14 VDD VSS sg13g2_decap_8
XFILLER_72_758 VDD VSS sg13g2_fill_2
Xclkbuf_leaf_36_clk clkbuf_4_14_0_clk/X _4979_/CLK VDD VSS sg13g2_buf_8
XFILLER_112_98 VDD VSS sg13g2_decap_8
XFILLER_13_803 VDD VSS sg13g2_decap_8
XFILLER_72_58 VDD VSS sg13g2_decap_8
XFILLER_24_173 VDD VSS sg13g2_decap_8
XFILLER_52_482 VDD VSS sg13g2_fill_2
XFILLER_72_69 VDD VSS sg13g2_fill_2
XFILLER_40_677 VDD VSS sg13g2_fill_1
XFILLER_8_317 VDD VSS sg13g2_fill_1
XFILLER_108_0 VDD VSS sg13g2_decap_8
XFILLER_106_484 VDD VSS sg13g2_decap_8
XFILLER_0_795 VDD VSS sg13g2_decap_8
XFILLER_48_722 VDD VSS sg13g2_decap_8
XFILLER_48_744 VDD VSS sg13g2_fill_2
XFILLER_87_390 VDD VSS sg13g2_decap_8
XFILLER_47_232 VDD VSS sg13g2_decap_8
XFILLER_47_265 VDD VSS sg13g2_decap_8
XFILLER_75_563 VDD VSS sg13g2_decap_8
XFILLER_35_438 VDD VSS sg13g2_decap_8
XFILLER_63_736 VDD VSS sg13g2_decap_8
XFILLER_62_235 VDD VSS sg13g2_decap_4
Xclkbuf_leaf_27_clk clkbuf_4_13_0_clk/X _4929_/CLK VDD VSS sg13g2_buf_8
XFILLER_90_544 VDD VSS sg13g2_decap_8
XFILLER_15_151 VDD VSS sg13g2_decap_8
XFILLER_50_419 VDD VSS sg13g2_decap_8
XFILLER_62_268 VDD VSS sg13g2_decap_8
XFILLER_90_577 VDD VSS sg13g2_decap_8
XFILLER_31_633 VDD VSS sg13g2_decap_8
X_2860_ _2860_/A0 _3095_/A0 _2869_/S _4295_/D VDD VSS sg13g2_mux2_1
XFILLER_30_154 VDD VSS sg13g2_decap_8
X_2791_ VSS VDD _2340_/Y _2789_/A _2791_/Y _2790_/Y sg13g2_a21oi_1
X_4530_ fanout299/X VSS VDD _4530_/D _4530_/Q _4976_/CLK sg13g2_dfrbpq_1
XFILLER_8_862 VDD VSS sg13g2_decap_8
XFILLER_7_75 VDD VSS sg13g2_decap_8
X_4461_ fanout306/X VSS VDD _4461_/D _4461_/Q _4975_/CLK sg13g2_dfrbpq_1
X_3412_ _3412_/B _3416_/A _4785_/Q _3412_/Y VDD VSS _3412_/D sg13g2_nand4_1
X_4392_ _4392_/RESET_B VSS VDD _4392_/D _4392_/Q _4973_/CLK sg13g2_dfrbpq_1
X_4359__367 VDD VSS _4359_/RESET_B sg13g2_tiehi
XFILLER_98_600 VDD VSS sg13g2_fill_1
X_3343_ VSS VDD _4902_/Q _4683_/Q _3343_/Y _3378_/B sg13g2_a21oi_1
XFILLER_98_655 VDD VSS sg13g2_fill_2
XFILLER_23_0 VDD VSS sg13g2_decap_4
Xhold1006 _3531_/X VDD VSS _4693_/D sg13g2_dlygate4sd3_1
X_3274_ VSS VDD _3275_/B hold744/X _3274_/Y _3281_/A sg13g2_a21oi_1
XFILLER_86_817 VDD VSS sg13g2_decap_8
XFILLER_100_638 VDD VSS sg13g2_decap_8
XFILLER_100_649 VDD VSS sg13g2_fill_1
Xhold1017 _4512_/Q VDD VSS _3012_/A1 sg13g2_dlygate4sd3_1
Xhold1028 _3034_/X VDD VSS _4460_/D sg13g2_dlygate4sd3_1
Xhold1039 _2940_/X VDD VSS _4370_/D sg13g2_dlygate4sd3_1
XFILLER_66_541 VDD VSS sg13g2_decap_8
XFILLER_26_18 VDD VSS sg13g2_fill_1
XFILLER_26_29 VDD VSS sg13g2_decap_8
XFILLER_81_566 VDD VSS sg13g2_fill_2
Xclkbuf_leaf_18_clk clkbuf_4_7_0_clk/X _4807_/CLK VDD VSS sg13g2_buf_8
XFILLER_50_920 VDD VSS sg13g2_decap_4
XFILLER_81_599 VDD VSS sg13g2_decap_8
XFILLER_21_121 VDD VSS sg13g2_fill_2
XFILLER_22_633 VDD VSS sg13g2_decap_8
XFILLER_34_493 VDD VSS sg13g2_fill_2
XFILLER_10_839 VDD VSS sg13g2_decap_8
X_2989_ hold880/X _3091_/A0 _3003_/S _2989_/X VDD VSS sg13g2_mux2_1
X_4728_ fanout323/X VSS VDD _4728_/D _4728_/Q _4729_/CLK sg13g2_dfrbpq_1
XFILLER_107_204 VDD VSS sg13g2_decap_8
XFILLER_108_738 VDD VSS sg13g2_decap_8
X_4659_ fanout254/X VSS VDD _4659_/D _4659_/Q _4673_/CLK sg13g2_dfrbpq_1
XFILLER_101_7 VDD VSS sg13g2_decap_8
XFILLER_116_782 VDD VSS sg13g2_decap_8
Xhold873 _3123_/X VDD VSS _4547_/D sg13g2_dlygate4sd3_1
Xhold862 _4407_/Q VDD VSS hold862/X sg13g2_dlygate4sd3_1
Xhold851 _4794_/Q VDD VSS hold851/X sg13g2_dlygate4sd3_1
Xhold840 _2987_/X VDD VSS _4414_/D sg13g2_dlygate4sd3_1
XFILLER_103_443 VDD VSS sg13g2_decap_8
XFILLER_115_292 VDD VSS sg13g2_fill_1
XFILLER_1_559 VDD VSS sg13g2_decap_8
XFILLER_67_14 VDD VSS sg13g2_decap_8
Xhold895 _4386_/Q VDD VSS hold895/X sg13g2_dlygate4sd3_1
Xhold884 _3008_/X VDD VSS _4435_/D sg13g2_dlygate4sd3_1
XFILLER_103_476 VDD VSS sg13g2_decap_8
XFILLER_76_305 VDD VSS sg13g2_decap_8
XFILLER_77_817 VDD VSS sg13g2_decap_8
XFILLER_77_828 VDD VSS sg13g2_fill_1
XFILLER_69_390 VDD VSS sg13g2_decap_8
XFILLER_29_254 VDD VSS sg13g2_decap_8
Xhold1540 _4609_/Q VDD VSS _3258_/A sg13g2_dlygate4sd3_1
Xhold1551 _2810_/Y VDD VSS _2811_/B sg13g2_dlygate4sd3_1
Xhold1562 _4718_/Q VDD VSS _3569_/A1 sg13g2_dlygate4sd3_1
XFILLER_85_850 VDD VSS sg13g2_decap_8
XFILLER_17_405 VDD VSS sg13g2_decap_8
XFILLER_57_585 VDD VSS sg13g2_decap_8
Xhold1573 _3165_/Y VDD VSS _3166_/B sg13g2_dlygate4sd3_1
Xhold1584 _4613_/Q VDD VSS _2613_/A sg13g2_dlygate4sd3_1
Xhold1595 _3148_/Y VDD VSS _4561_/D sg13g2_dlygate4sd3_1
XFILLER_33_909 VDD VSS sg13g2_decap_8
XFILLER_45_769 VDD VSS sg13g2_fill_1
XFILLER_72_544 VDD VSS sg13g2_decap_4
XFILLER_83_46 VDD VSS sg13g2_decap_8
XFILLER_41_920 VDD VSS sg13g2_decap_4
XFILLER_13_655 VDD VSS sg13g2_decap_8
XFILLER_40_441 VDD VSS sg13g2_decap_8
XFILLER_5_865 VDD VSS sg13g2_decap_8
XFILLER_107_782 VDD VSS sg13g2_decap_8
XFILLER_110_925 VDD VSS sg13g2_fill_1
XFILLER_0_592 VDD VSS sg13g2_decap_8
XFILLER_95_636 VDD VSS sg13g2_decap_8
XFILLER_48_552 VDD VSS sg13g2_fill_2
XFILLER_76_872 VDD VSS sg13g2_decap_8
XFILLER_36_725 VDD VSS sg13g2_decap_8
XFILLER_35_224 VDD VSS sg13g2_fill_1
XFILLER_63_544 VDD VSS sg13g2_decap_8
XFILLER_75_393 VDD VSS sg13g2_decap_8
XFILLER_91_864 VDD VSS sg13g2_decap_8
XFILLER_91_842 VDD VSS sg13g2_decap_4
XFILLER_23_408 VDD VSS sg13g2_decap_8
XFILLER_51_717 VDD VSS sg13g2_decap_8
X_3961_ _3961_/Y _3960_/X _3956_/A _3959_/Y _2483_/A VDD VSS sg13g2_a22oi_1
XFILLER_91_897 VDD VSS sg13g2_decap_8
XFILLER_16_482 VDD VSS sg13g2_decap_8
XFILLER_32_920 VDD VSS sg13g2_decap_4
XFILLER_50_249 VDD VSS sg13g2_decap_8
XFILLER_73_90 VDD VSS sg13g2_decap_4
X_2912_ hold961/X _3094_/A0 _2928_/S _2912_/X VDD VSS sg13g2_mux2_1
XFILLER_90_396 VDD VSS sg13g2_decap_8
XFILLER_31_452 VDD VSS sg13g2_decap_8
XFILLER_43_290 VDD VSS sg13g2_decap_8
X_3892_ _3891_/Y VDD _3892_/Y VSS _2486_/A _3907_/B sg13g2_o21ai_1
X_2843_ hold921/X _3105_/A0 _2846_/S _4280_/D VDD VSS sg13g2_mux2_1
X_2774_ _2774_/A _2774_/B _2780_/C VDD VSS sg13g2_nor2_1
X_4513_ fanout265/X VSS VDD _4513_/D _4513_/Q clkload8/A sg13g2_dfrbpq_1
Xclkbuf_leaf_7_clk clkbuf_4_6_0_clk/X _4559_/CLK VDD VSS sg13g2_buf_8
X_4444_ _4444_/RESET_B VSS VDD _4444_/D _4444_/Q _4817_/CLK sg13g2_dfrbpq_1
X_4375_ _4375_/RESET_B VSS VDD _4375_/D _4375_/Q _4977_/CLK sg13g2_dfrbpq_1
X_3326_ _4788_/Q _3406_/A _3326_/C _3326_/D _3327_/B VDD VSS sg13g2_and4_1
XFILLER_85_124 VDD VSS sg13g2_decap_8
XFILLER_98_496 VDD VSS sg13g2_decap_8
XFILLER_86_647 VDD VSS sg13g2_fill_1
XFILLER_37_28 VDD VSS sg13g2_decap_8
XFILLER_39_541 VDD VSS sg13g2_fill_2
XFILLER_85_168 VDD VSS sg13g2_decap_8
X_3257_ VSS VDD _3255_/X _3256_/X _4608_/D _3289_/A sg13g2_a21oi_1
XFILLER_39_563 VDD VSS sg13g2_decap_4
X_3188_ _2515_/B VDD _3188_/Y VSS _4578_/Q _3186_/B sg13g2_o21ai_1
XFILLER_54_555 VDD VSS sg13g2_fill_1
XFILLER_82_864 VDD VSS sg13g2_decap_8
XFILLER_26_268 VDD VSS sg13g2_decap_8
XFILLER_42_706 VDD VSS sg13g2_decap_8
XFILLER_53_49 VDD VSS sg13g2_decap_8
XFILLER_41_249 VDD VSS sg13g2_decap_8
XFILLER_108_546 VDD VSS sg13g2_decap_8
XFILLER_2_813 VDD VSS sg13g2_decap_8
Xhold681 _2770_/Y VDD VSS _2773_/A sg13g2_dlygate4sd3_1
Xhold670 _4963_/Q VDD VSS _2352_/A sg13g2_dlygate4sd3_1
XFILLER_104_774 VDD VSS sg13g2_decap_8
XFILLER_1_345 VDD VSS sg13g2_decap_8
Xhold692 _2803_/Y VDD VSS _4910_/D sg13g2_dlygate4sd3_1
XFILLER_65_809 VDD VSS sg13g2_decap_8
XFILLER_76_157 VDD VSS sg13g2_decap_8
XFILLER_77_658 VDD VSS sg13g2_decap_8
XFILLER_77_669 VDD VSS sg13g2_fill_2
XFILLER_58_883 VDD VSS sg13g2_decap_4
Xhold1370 _4792_/Q VDD VSS _2319_/A sg13g2_dlygate4sd3_1
XFILLER_91_116 VDD VSS sg13g2_decap_8
XFILLER_73_842 VDD VSS sg13g2_decap_8
Xhold1381 _4912_/Q VDD VSS _2433_/A sg13g2_dlygate4sd3_1
Xhold1392 _4844_/Q VDD VSS _2470_/D sg13g2_dlygate4sd3_1
XFILLER_45_577 VDD VSS sg13g2_fill_1
XFILLER_32_238 VDD VSS sg13g2_decap_8
X_4349__377 VDD VSS _4349_/RESET_B sg13g2_tiehi
XFILLER_9_401 VDD VSS sg13g2_decap_8
XFILLER_43_93 VDD VSS sg13g2_decap_4
XFILLER_64_7 VDD VSS sg13g2_decap_8
XFILLER_5_662 VDD VSS sg13g2_fill_1
X_2490_ _3563_/B _4718_/Q _4717_/Q _2703_/A VDD VSS sg13g2_nand3_1
XFILLER_4_183 VDD VSS sg13g2_decap_8
XFILLER_4_21 VDD VSS sg13g2_decap_8
X_4160_ _4226_/S1 VDD _4160_/Y VSS _4250_/A1 _4351_/Q sg13g2_o21ai_1
XFILLER_96_912 VDD VSS sg13g2_decap_8
XFILLER_110_733 VDD VSS sg13g2_decap_8
X_3111_ _4535_/D _3142_/B hold606/X VDD VSS sg13g2_nand2b_1
XFILLER_49_850 VDD VSS sg13g2_decap_8
X_4091_ _4199_/A1 VDD _4091_/Y VSS _4196_/A1 _4394_/Q sg13g2_o21ai_1
XFILLER_36_511 VDD VSS sg13g2_decap_8
XFILLER_48_371 VDD VSS sg13g2_decap_8
X_3042_ _3553_/A1 _3067_/A _3058_/S _4468_/D VDD VSS sg13g2_mux2_1
XFILLER_64_831 VDD VSS sg13g2_decap_8
XFILLER_24_706 VDD VSS sg13g2_fill_1
XFILLER_24_717 VDD VSS sg13g2_fill_1
XFILLER_51_525 VDD VSS sg13g2_decap_8
XFILLER_91_694 VDD VSS sg13g2_decap_4
X_3944_ _3944_/B _3944_/C _3944_/A _3944_/Y VDD VSS sg13g2_nand3_1
XFILLER_90_0 VDD VSS sg13g2_decap_8
XFILLER_20_923 VDD VSS sg13g2_fill_2
XFILLER_32_772 VDD VSS sg13g2_decap_8
XFILLER_32_783 VDD VSS sg13g2_fill_1
X_3875_ VSS VDD _3879_/D _3873_/Y _3875_/Y hold800/X sg13g2_a21oi_1
X_2826_ _2826_/A0 _3088_/A0 _2846_/S _4263_/D VDD VSS sg13g2_mux2_1
X_2757_ _2757_/Y _3728_/C _3728_/A VDD VSS sg13g2_nand2b_1
X_2688_ _3563_/B _2702_/B _4717_/Q _2689_/D VDD VSS _2688_/D sg13g2_nand4_1
X_4427_ _4427_/RESET_B VSS VDD _4427_/D _4427_/Q _4971_/CLK sg13g2_dfrbpq_1
X_4358_ _4358_/RESET_B VSS VDD _4358_/D _4358_/Q _4397_/CLK sg13g2_dfrbpq_1
XFILLER_98_282 VDD VSS sg13g2_decap_8
XFILLER_86_400 VDD VSS sg13g2_fill_2
XFILLER_58_157 VDD VSS sg13g2_fill_1
XFILLER_59_658 VDD VSS sg13g2_fill_2
X_4454__472 VDD VSS _4454_/RESET_B sg13g2_tiehi
X_4289_ _4289_/RESET_B VSS VDD _4289_/D _4289_/Q clkload8/A sg13g2_dfrbpq_1
X_3309_ _4782_/Q _4783_/Q _3396_/B VDD VSS sg13g2_nor2_1
XFILLER_86_466 VDD VSS sg13g2_decap_8
XFILLER_101_788 VDD VSS sg13g2_decap_8
XFILLER_104_22 VDD VSS sg13g2_decap_8
XFILLER_46_319 VDD VSS sg13g2_decap_8
XFILLER_104_77 VDD VSS sg13g2_fill_2
XFILLER_27_522 VDD VSS sg13g2_fill_2
XFILLER_27_544 VDD VSS sg13g2_decap_8
XFILLER_39_393 VDD VSS sg13g2_decap_4
XFILLER_73_127 VDD VSS sg13g2_fill_1
XFILLER_15_706 VDD VSS sg13g2_decap_8
XFILLER_54_341 VDD VSS sg13g2_decap_8
XFILLER_55_875 VDD VSS sg13g2_decap_8
XFILLER_14_227 VDD VSS sg13g2_decap_8
XFILLER_70_845 VDD VSS sg13g2_decap_8
XFILLER_70_856 VDD VSS sg13g2_fill_2
XFILLER_11_901 VDD VSS sg13g2_decap_8
XFILLER_30_709 VDD VSS sg13g2_decap_8
XFILLER_70_878 VDD VSS sg13g2_decap_8
XFILLER_80_14 VDD VSS sg13g2_decap_8
Xfanout31 _2603_/Y _2604_/A VDD VSS sg13g2_buf_1
XFILLER_23_761 VDD VSS sg13g2_fill_2
Xfanout42 _3953_/A _3939_/C VDD VSS sg13g2_buf_1
Xfanout53 _3443_/C _3475_/C VDD VSS sg13g2_buf_1
Xfanout64 fanout67/X _3136_/B VDD VSS sg13g2_buf_1
XFILLER_22_293 VDD VSS sg13g2_decap_8
Xfanout75 _3306_/X _3473_/B VDD VSS sg13g2_buf_1
Xfanout86 fanout88/X _2981_/S VDD VSS sg13g2_buf_1
Xfanout97 fanout98/X _2922_/S VDD VSS sg13g2_buf_1
XFILLER_109_811 VDD VSS sg13g2_decap_8
XFILLER_109_833 VDD VSS sg13g2_decap_4
XFILLER_13_74 VDD VSS sg13g2_fill_2
XFILLER_109_855 VDD VSS sg13g2_fill_1
XFILLER_108_354 VDD VSS sg13g2_decap_8
XFILLER_1_142 VDD VSS sg13g2_decap_8
XFILLER_49_102 VDD VSS sg13g2_decap_8
XFILLER_49_157 VDD VSS sg13g2_decap_8
XFILLER_89_293 VDD VSS sg13g2_fill_2
XFILLER_58_680 VDD VSS sg13g2_decap_8
XFILLER_72_171 VDD VSS sg13g2_decap_8
XFILLER_72_182 VDD VSS sg13g2_decap_8
XFILLER_33_569 VDD VSS sg13g2_decap_8
XFILLER_61_878 VDD VSS sg13g2_decap_8
XFILLER_60_399 VDD VSS sg13g2_decap_8
XFILLER_13_293 VDD VSS sg13g2_decap_8
XFILLER_9_242 VDD VSS sg13g2_decap_8
X_3660_ _4732_/Q _4731_/Q _3705_/B VDD VSS sg13g2_nor2_1
Xclkload12 VDD clkload12/Y _4841_/CLK VSS sg13g2_inv_1
Xclkload23 _4971_/CLK clkload23/X VDD VSS sg13g2_buf_8
Xclkload34 clkload34/Y _4965_/CLK VDD VSS sg13g2_inv_2
X_3591_ VSS VDD _3592_/B _3603_/D _3591_/Y _3602_/A sg13g2_a21oi_1
X_2611_ _3258_/A _2611_/B _3263_/A _3258_/B _2615_/C VDD VSS sg13g2_nor4_1
XFILLER_115_825 VDD VSS sg13g2_fill_2
X_2542_ _2546_/D _2543_/A _2542_/X VDD VSS sg13g2_xor2_1
XFILLER_114_379 VDD VSS sg13g2_decap_8
X_4212_ _4251_/S _4281_/Q _4306_/Q _4331_/Q _4356_/Q _4250_/B1 _4212_/X VDD VSS sg13g2_mux4_1
X_2473_ _3877_/B _3871_/A _2473_/B VDD VSS sg13g2_nand2_1
XFILLER_68_411 VDD VSS sg13g2_decap_8
X_4143_ _4232_/B1 VDD _4143_/Y VSS _4205_/A1 _4143_/A2 sg13g2_o21ai_1
XFILLER_55_116 VDD VSS sg13g2_decap_8
X_4074_ _4118_/S _4367_/Q _4074_/Y VDD VSS sg13g2_nor2_1
XFILLER_49_680 VDD VSS sg13g2_decap_8
X_3025_ _4451_/Q hold845/X _3034_/S _3025_/X VDD VSS sg13g2_mux2_1
XFILLER_37_864 VDD VSS sg13g2_decap_8
XFILLER_52_801 VDD VSS sg13g2_decap_8
XFILLER_52_812 VDD VSS sg13g2_fill_2
XFILLER_64_672 VDD VSS sg13g2_decap_8
XFILLER_83_469 VDD VSS sg13g2_fill_1
XFILLER_12_709 VDD VSS sg13g2_decap_8
X_4976_ fanout298/X VSS VDD _4976_/D _4976_/Q _4976_/CLK sg13g2_dfrbpq_1
X_3927_ _3936_/A _3936_/B _3939_/D VDD VSS sg13g2_nor2_1
XFILLER_20_775 VDD VSS sg13g2_decap_8
Xclkload6 clkload6/Y clkload6/A VDD VSS sg13g2_inv_2
X_3858_ hold996/X hold857/X _4856_/D _4795_/D VDD VSS sg13g2_mux2_1
X_3789_ _3789_/Y _3789_/A _3789_/B VDD VSS sg13g2_nand2_1
X_2809_ _4918_/D _2809_/A _2809_/B _2809_/C VDD VSS sg13g2_and3_1
XFILLER_106_803 VDD VSS sg13g2_fill_2
XFILLER_59_48 VDD VSS sg13g2_decap_8
XFILLER_78_208 VDD VSS sg13g2_decap_8
XFILLER_115_21 VDD VSS sg13g2_decap_8
Xfanout210 hold1459/X _3635_/B VDD VSS sg13g2_buf_1
Xfanout221 _4534_/Q _3110_/A0 VDD VSS sg13g2_buf_1
Xfanout232 _4523_/Q _3023_/A1 VDD VSS sg13g2_buf_1
XFILLER_101_541 VDD VSS sg13g2_decap_8
XFILLER_113_390 VDD VSS sg13g2_fill_2
Xfanout243 _3012_/A1 _3088_/A0 VDD VSS sg13g2_buf_1
Xfanout254 fanout255/X fanout254/X VDD VSS sg13g2_buf_1
Xfanout265 fanout266/X fanout265/X VDD VSS sg13g2_buf_1
X_4339__387 VDD VSS _4339_/RESET_B sg13g2_tiehi
XFILLER_101_574 VDD VSS sg13g2_decap_4
XFILLER_19_319 VDD VSS sg13g2_fill_2
XFILLER_74_414 VDD VSS sg13g2_fill_2
Xfanout276 fanout278/X fanout276/X VDD VSS sg13g2_buf_1
Xfanout287 fanout294/X fanout287/X VDD VSS sg13g2_buf_1
Xfanout298 fanout300/X fanout298/X VDD VSS sg13g2_buf_1
XFILLER_87_775 VDD VSS sg13g2_decap_8
XFILLER_28_820 VDD VSS sg13g2_decap_8
XFILLER_74_425 VDD VSS sg13g2_fill_1
XFILLER_74_436 VDD VSS sg13g2_fill_2
XFILLER_75_58 VDD VSS sg13g2_decap_8
XFILLER_86_285 VDD VSS sg13g2_decap_4
XFILLER_39_190 VDD VSS sg13g2_decap_8
XFILLER_55_650 VDD VSS sg13g2_fill_1
XFILLER_90_918 VDD VSS sg13g2_decap_8
XFILLER_15_536 VDD VSS sg13g2_decap_8
XFILLER_43_823 VDD VSS sg13g2_decap_8
XFILLER_55_683 VDD VSS sg13g2_decap_8
X_4385__341 VDD VSS _4385_/RESET_B sg13g2_tiehi
XFILLER_91_35 VDD VSS sg13g2_decap_8
XFILLER_42_377 VDD VSS sg13g2_decap_4
XFILLER_10_252 VDD VSS sg13g2_decap_8
XFILLER_109_641 VDD VSS sg13g2_decap_8
XFILLER_6_212 VDD VSS sg13g2_decap_8
XFILLER_6_256 VDD VSS sg13g2_decap_4
XFILLER_108_162 VDD VSS sg13g2_decap_8
XFILLER_97_539 VDD VSS sg13g2_decap_8
XFILLER_27_7 VDD VSS sg13g2_fill_1
XFILLER_49_70 VDD VSS sg13g2_decap_8
XFILLER_38_606 VDD VSS sg13g2_decap_4
XFILLER_38_628 VDD VSS sg13g2_fill_1
XFILLER_93_701 VDD VSS sg13g2_decap_8
XFILLER_19_875 VDD VSS sg13g2_decap_8
XFILLER_37_149 VDD VSS sg13g2_fill_1
XFILLER_92_255 VDD VSS sg13g2_decap_4
XFILLER_18_363 VDD VSS sg13g2_decap_8
XFILLER_65_91 VDD VSS sg13g2_decap_8
XFILLER_92_299 VDD VSS sg13g2_decap_8
XFILLER_45_182 VDD VSS sg13g2_decap_8
XFILLER_60_130 VDD VSS sg13g2_decap_8
X_4830_ fanout270/X VSS VDD _4830_/D _4830_/Q _4942_/CLK sg13g2_dfrbpq_1
XFILLER_33_388 VDD VSS sg13g2_decap_8
XFILLER_81_90 VDD VSS sg13g2_decap_8
X_4761_ fanout249/X VSS VDD _4761_/D _4761_/Q clkload0/A sg13g2_dfrbpq_1
X_4692_ fanout322/X VSS VDD _4692_/D _4692_/Q _4868_/CLK sg13g2_dfrbpq_1
X_4444__482 VDD VSS _4444_/RESET_B sg13g2_tiehi
X_3712_ _4743_/Q _4744_/Q _3712_/C _3712_/Y VDD VSS sg13g2_nor3_1
X_3643_ _3722_/A _3643_/B _3643_/X VDD VSS sg13g2_and2_1
XFILLER_114_110 VDD VSS sg13g2_decap_8
XFILLER_53_0 VDD VSS sg13g2_decap_8
X_3574_ _3574_/A _3601_/B _3580_/B VDD VSS sg13g2_nor2_1
XFILLER_115_655 VDD VSS sg13g2_decap_8
X_2525_ VSS VDD _3743_/A _3745_/C _3746_/A _3796_/B sg13g2_a21oi_1
XFILLER_103_839 VDD VSS sg13g2_decap_8
XFILLER_114_176 VDD VSS sg13g2_decap_4
X_2456_ _2470_/A _2470_/B _4931_/D VDD VSS sg13g2_nor2_1
XFILLER_102_349 VDD VSS sg13g2_decap_8
XFILLER_111_850 VDD VSS sg13g2_decap_8
XFILLER_29_18 VDD VSS sg13g2_decap_8
XFILLER_69_753 VDD VSS sg13g2_decap_8
XFILLER_111_861 VDD VSS sg13g2_fill_2
XFILLER_29_617 VDD VSS sg13g2_decap_8
X_4126_ _4372_/Q _4397_/Q _4231_/A _4126_/X VDD VSS sg13g2_mux2_1
X_2387_ _2387_/B _2387_/C _2387_/A _2388_/D VDD VSS _2387_/D sg13g2_nand4_1
XFILLER_96_583 VDD VSS sg13g2_decap_8
XFILLER_84_745 VDD VSS sg13g2_fill_1
X_4451__475 VDD VSS _4451_/RESET_B sg13g2_tiehi
XFILLER_45_28 VDD VSS sg13g2_decap_4
X_4057_ _4057_/Y _4057_/B _4078_/A VDD VSS sg13g2_nand2b_1
XFILLER_25_823 VDD VSS sg13g2_fill_1
XFILLER_71_439 VDD VSS sg13g2_decap_8
X_3008_ hold883/X _3110_/A0 _3008_/S _3008_/X VDD VSS sg13g2_mux2_1
XFILLER_25_867 VDD VSS sg13g2_decap_8
XFILLER_12_506 VDD VSS sg13g2_fill_2
XFILLER_24_355 VDD VSS sg13g2_decap_4
XFILLER_52_697 VDD VSS sg13g2_fill_1
XFILLER_101_89 VDD VSS sg13g2_decap_8
XFILLER_24_399 VDD VSS sg13g2_decap_8
XFILLER_61_49 VDD VSS sg13g2_decap_4
X_4959_ fanout312/X VSS VDD _4959_/D _4959_/Q _4959_/CLK sg13g2_dfrbpq_1
XFILLER_106_622 VDD VSS sg13g2_decap_8
XFILLER_105_132 VDD VSS sg13g2_decap_4
XFILLER_3_237 VDD VSS sg13g2_decap_8
XFILLER_0_900 VDD VSS sg13g2_decap_8
XFILLER_105_187 VDD VSS sg13g2_fill_1
XFILLER_106_688 VDD VSS sg13g2_decap_8
XFILLER_75_712 VDD VSS sg13g2_decap_8
XFILLER_101_393 VDD VSS sg13g2_fill_2
XFILLER_74_222 VDD VSS sg13g2_decap_8
XFILLER_74_255 VDD VSS sg13g2_decap_8
XFILLER_75_778 VDD VSS sg13g2_decap_8
XFILLER_28_683 VDD VSS sg13g2_decap_8
XFILLER_74_299 VDD VSS sg13g2_decap_8
XFILLER_16_867 VDD VSS sg13g2_decap_8
XFILLER_35_50 VDD VSS sg13g2_fill_1
XFILLER_42_141 VDD VSS sg13g2_decap_8
XFILLER_43_686 VDD VSS sg13g2_decap_8
XFILLER_42_185 VDD VSS sg13g2_decap_8
XFILLER_116_408 VDD VSS sg13g2_decap_8
XFILLER_109_482 VDD VSS sg13g2_decap_8
XFILLER_7_598 VDD VSS sg13g2_decap_8
X_3290_ _2618_/Y hold729/X _4942_/Q _3290_/X VDD VSS sg13g2_a21o_1
X_2310_ VDD _3424_/A _4775_/Q VSS sg13g2_inv_1
XFILLER_97_303 VDD VSS sg13g2_decap_8
XFILLER_111_113 VDD VSS sg13g2_decap_8
XFILLER_3_793 VDD VSS sg13g2_decap_8
X_2241_ VDD _2241_/Y _2474_/D VSS sg13g2_inv_1
XFILLER_39_915 VDD VSS sg13g2_decap_8
XFILLER_78_561 VDD VSS sg13g2_decap_8
XFILLER_85_509 VDD VSS sg13g2_fill_1
XFILLER_38_436 VDD VSS sg13g2_fill_1
XFILLER_93_520 VDD VSS sg13g2_fill_1
XFILLER_38_469 VDD VSS sg13g2_decap_8
XFILLER_65_266 VDD VSS sg13g2_fill_1
XFILLER_66_789 VDD VSS sg13g2_decap_8
XFILLER_93_553 VDD VSS sg13g2_decap_8
XFILLER_19_683 VDD VSS sg13g2_decap_8
XFILLER_34_642 VDD VSS sg13g2_decap_8
XFILLER_33_163 VDD VSS sg13g2_decap_8
XFILLER_21_336 VDD VSS sg13g2_decap_8
X_4813_ fanout313/X VSS VDD _4813_/D _4813_/Q _4824_/CLK sg13g2_dfrbpq_1
X_4744_ fanout272/X VSS VDD _4744_/D _4744_/Q _4745_/CLK sg13g2_dfrbpq_1
X_4329__397 VDD VSS _4329_/RESET_B sg13g2_tiehi
X_4675_ fanout254/X VSS VDD _4675_/D _4675_/Q clkload4/A sg13g2_dfrbpq_1
X_3626_ _3626_/A _3640_/B _3626_/Y VDD VSS sg13g2_nor2_1
Xoutput19 _4928_/Q rec_done VDD VSS sg13g2_buf_1
X_3557_ _3558_/A _3558_/B _3610_/B VDD VSS sg13g2_nor2_1
XFILLER_89_815 VDD VSS sg13g2_decap_8
XFILLER_115_474 VDD VSS sg13g2_decap_8
XFILLER_1_719 VDD VSS sg13g2_decap_8
X_2508_ _2508_/A _3162_/A _2508_/C _2508_/D _3167_/B VDD VSS sg13g2_and4_1
X_4375__351 VDD VSS _4375_/RESET_B sg13g2_tiehi
X_3488_ _3487_/Y VDD _4681_/D VSS _2289_/Y _3490_/S sg13g2_o21ai_1
XFILLER_89_859 VDD VSS sg13g2_decap_8
XFILLER_69_572 VDD VSS sg13g2_fill_1
X_2439_ _2433_/C VDD _2439_/Y VSS _2432_/C _2805_/B sg13g2_o21ai_1
XFILLER_96_391 VDD VSS sg13g2_decap_8
XFILLER_29_458 VDD VSS sg13g2_decap_8
XFILLER_56_255 VDD VSS sg13g2_fill_2
XFILLER_56_49 VDD VSS sg13g2_decap_8
X_4109_ _4109_/Y _4109_/B _4078_/A VDD VSS sg13g2_nand2b_1
XFILLER_16_108 VDD VSS sg13g2_decap_4
XFILLER_56_266 VDD VSS sg13g2_decap_8
XFILLER_71_203 VDD VSS sg13g2_fill_2
XFILLER_71_214 VDD VSS sg13g2_decap_8
XFILLER_72_737 VDD VSS sg13g2_decap_8
XFILLER_112_66 VDD VSS sg13g2_fill_2
XFILLER_13_826 VDD VSS sg13g2_fill_1
XFILLER_24_152 VDD VSS sg13g2_decap_8
XFILLER_40_612 VDD VSS sg13g2_fill_2
X_4382__344 VDD VSS _4382_/RESET_B sg13g2_tiehi
XFILLER_20_380 VDD VSS sg13g2_fill_2
XFILLER_20_391 VDD VSS sg13g2_decap_8
XFILLER_107_920 VDD VSS sg13g2_decap_4
XFILLER_21_41 VDD VSS sg13g2_decap_8
XFILLER_21_85 VDD VSS sg13g2_decap_8
XFILLER_4_546 VDD VSS sg13g2_fill_1
XFILLER_97_56 VDD VSS sg13g2_decap_8
XFILLER_0_774 VDD VSS sg13g2_decap_8
XFILLER_94_306 VDD VSS sg13g2_decap_8
XFILLER_88_870 VDD VSS sg13g2_decap_8
XFILLER_36_907 VDD VSS sg13g2_decap_8
X_4434__492 VDD VSS _4434_/RESET_B sg13g2_tiehi
XFILLER_46_60 VDD VSS sg13g2_decap_8
XFILLER_62_214 VDD VSS sg13g2_decap_8
XFILLER_63_715 VDD VSS sg13g2_decap_8
XFILLER_15_130 VDD VSS sg13g2_decap_8
XFILLER_30_111 VDD VSS sg13g2_decap_8
XFILLER_43_494 VDD VSS sg13g2_decap_8
XFILLER_94_7 VDD VSS sg13g2_decap_8
XFILLER_31_667 VDD VSS sg13g2_decap_4
XFILLER_12_881 VDD VSS sg13g2_decap_8
X_2790_ _2790_/A _4868_/D _2790_/Y VDD VSS sg13g2_nor2_1
XFILLER_8_841 VDD VSS sg13g2_decap_8
XFILLER_7_54 VDD VSS sg13g2_decap_8
X_4460_ _4460_/RESET_B VSS VDD _4460_/D _4460_/Q _4961_/CLK sg13g2_dfrbpq_1
X_4441__485 VDD VSS _4441_/RESET_B sg13g2_tiehi
XFILLER_116_249 VDD VSS sg13g2_decap_8
X_4391_ _4391_/RESET_B VSS VDD _4391_/D _4391_/Q _4958_/CLK sg13g2_dfrbpq_1
X_3411_ _4784_/Q _3411_/B _3415_/B _3412_/D VDD VSS sg13g2_nor3_1
X_3342_ _3489_/B _4775_/Q _3342_/Y VDD VSS _3378_/C sg13g2_nand3b_1
XFILLER_98_634 VDD VSS sg13g2_decap_8
XFILLER_100_617 VDD VSS sg13g2_decap_8
XFILLER_112_466 VDD VSS sg13g2_decap_8
XFILLER_85_306 VDD VSS sg13g2_decap_8
X_3273_ _3273_/Y _3273_/B _2613_/Y VDD VSS sg13g2_nand2b_1
XFILLER_112_499 VDD VSS sg13g2_decap_8
XFILLER_85_339 VDD VSS sg13g2_decap_8
Xhold1007 _4449_/Q VDD VSS _4143_/A2 sg13g2_dlygate4sd3_1
Xhold1018 _4292_/Q VDD VSS _2857_/A0 sg13g2_dlygate4sd3_1
Xhold1029 _4490_/Q VDD VSS _3064_/A1 sg13g2_dlygate4sd3_1
XFILLER_97_188 VDD VSS sg13g2_decap_8
XFILLER_16_0 VDD VSS sg13g2_decap_4
XFILLER_27_918 VDD VSS sg13g2_decap_8
XFILLER_94_884 VDD VSS sg13g2_decap_8
XFILLER_22_612 VDD VSS sg13g2_decap_8
XFILLER_61_280 VDD VSS sg13g2_decap_8
XFILLER_22_689 VDD VSS sg13g2_decap_8
X_2988_ hold973/X _3090_/A0 _3008_/S _2988_/X VDD VSS sg13g2_mux2_1
X_4727_ fanout328/X VSS VDD _4727_/D _4727_/Q _4729_/CLK sg13g2_dfrbpq_1
X_4658_ fanout265/X VSS VDD _4658_/D _4658_/Q _4658_/CLK sg13g2_dfrbpq_1
Xhold830 _2942_/X VDD VSS _4372_/D sg13g2_dlygate4sd3_1
X_3609_ _3610_/B _3607_/A _3608_/Y _3609_/X VDD VSS sg13g2_a21o_1
XFILLER_116_761 VDD VSS sg13g2_decap_8
Xhold863 _4364_/Q VDD VSS hold863/X sg13g2_dlygate4sd3_1
Xhold852 _4315_/Q VDD VSS _4046_/B sg13g2_dlygate4sd3_1
Xhold841 _4536_/Q VDD VSS hold841/X sg13g2_dlygate4sd3_1
X_4589_ fanout280/X VSS VDD _4589_/D _4589_/Q _4946_/CLK sg13g2_dfrbpq_1
XFILLER_89_612 VDD VSS sg13g2_decap_8
XFILLER_103_422 VDD VSS sg13g2_decap_8
XFILLER_115_271 VDD VSS sg13g2_decap_8
XFILLER_1_538 VDD VSS sg13g2_decap_8
Xhold896 _4522_/Q VDD VSS hold896/X sg13g2_dlygate4sd3_1
Xhold885 _4778_/Q VDD VSS _2326_/A sg13g2_dlygate4sd3_1
Xhold874 _4550_/Q VDD VSS hold874/X sg13g2_dlygate4sd3_1
XFILLER_88_111 VDD VSS sg13g2_decap_8
XFILLER_29_233 VDD VSS sg13g2_decap_8
Xhold1530 _3159_/Y VDD VSS _4566_/D sg13g2_dlygate4sd3_1
Xhold1541 _3258_/X VDD VSS _3259_/B sg13g2_dlygate4sd3_1
Xhold1552 _4608_/Q VDD VSS _2305_/A sg13g2_dlygate4sd3_1
XFILLER_45_737 VDD VSS sg13g2_fill_1
XFILLER_57_564 VDD VSS sg13g2_decap_8
XFILLER_72_523 VDD VSS sg13g2_decap_8
Xhold1563 _3569_/X VDD VSS _4718_/D sg13g2_dlygate4sd3_1
Xhold1574 _4582_/Q VDD VSS _3195_/B sg13g2_dlygate4sd3_1
Xhold1585 _2613_/Y VDD VSS _3271_/A sg13g2_dlygate4sd3_1
XFILLER_44_236 VDD VSS sg13g2_decap_8
Xhold1596 _4645_/Q VDD VSS _3369_/A1 sg13g2_dlygate4sd3_1
XFILLER_25_461 VDD VSS sg13g2_decap_8
XFILLER_13_634 VDD VSS sg13g2_decap_8
XFILLER_16_74 VDD VSS sg13g2_decap_8
XFILLER_12_122 VDD VSS sg13g2_decap_4
XFILLER_5_844 VDD VSS sg13g2_decap_8
XFILLER_107_761 VDD VSS sg13g2_decap_8
XFILLER_4_354 VDD VSS sg13g2_decap_8
XFILLER_79_100 VDD VSS sg13g2_decap_8
XFILLER_68_818 VDD VSS sg13g2_decap_8
XFILLER_68_829 VDD VSS sg13g2_fill_1
XFILLER_79_155 VDD VSS sg13g2_fill_2
XFILLER_0_571 VDD VSS sg13g2_decap_8
XFILLER_79_188 VDD VSS sg13g2_decap_8
XFILLER_36_704 VDD VSS sg13g2_decap_8
XFILLER_91_810 VDD VSS sg13g2_decap_4
X_3960_ _2480_/B _2247_/A _3929_/A _3960_/X VDD VSS sg13g2_a21o_1
XFILLER_90_375 VDD VSS sg13g2_decap_8
XFILLER_90_342 VDD VSS sg13g2_fill_2
XFILLER_16_461 VDD VSS sg13g2_decap_8
X_2911_ _2911_/A0 _3017_/A1 _2926_/S _4343_/D VDD VSS sg13g2_mux2_1
XFILLER_31_431 VDD VSS sg13g2_decap_8
X_3891_ _3891_/Y _3891_/B _3888_/Y VDD VSS sg13g2_nand2b_1
X_4365__361 VDD VSS _4365_/RESET_B sg13g2_tiehi
X_2842_ hold987/X _3104_/A0 _2842_/S _4279_/D VDD VSS sg13g2_mux2_1
X_2773_ _2773_/A _2773_/B _2773_/Y VDD VSS sg13g2_nor2_1
X_4512_ fanout263/X VSS VDD _4512_/D _4512_/Q _4926_/CLK sg13g2_dfrbpq_1
X_4443_ _4443_/RESET_B VSS VDD _4443_/D _4443_/Q clkload6/A sg13g2_dfrbpq_1
XFILLER_99_910 VDD VSS sg13g2_decap_8
XFILLER_113_731 VDD VSS sg13g2_decap_8
X_4374_ _4374_/RESET_B VSS VDD _4374_/D _4374_/Q _4968_/CLK sg13g2_dfrbpq_1
XFILLER_59_818 VDD VSS sg13g2_decap_4
X_3325_ _3399_/B _3399_/C _3325_/A _3326_/D VDD VSS sg13g2_nand3_1
XFILLER_98_475 VDD VSS sg13g2_decap_8
XFILLER_112_274 VDD VSS sg13g2_fill_2
X_3256_ _3278_/A _3258_/B _3256_/X VDD VSS sg13g2_and2_1
XFILLER_86_626 VDD VSS sg13g2_decap_4
X_4372__354 VDD VSS _4372_/RESET_B sg13g2_tiehi
XFILLER_67_884 VDD VSS sg13g2_fill_2
XFILLER_82_821 VDD VSS sg13g2_fill_2
X_3187_ _3145_/B VDD _3187_/Y VSS _3144_/A _3187_/A2 sg13g2_o21ai_1
XFILLER_23_921 VDD VSS sg13g2_decap_4
XFILLER_35_792 VDD VSS sg13g2_decap_4
XFILLER_53_28 VDD VSS sg13g2_decap_8
XFILLER_50_762 VDD VSS sg13g2_decap_4
XFILLER_10_626 VDD VSS sg13g2_fill_1
XFILLER_22_475 VDD VSS sg13g2_decap_4
XFILLER_108_525 VDD VSS sg13g2_decap_8
XFILLER_78_14 VDD VSS sg13g2_decap_8
XFILLER_116_580 VDD VSS sg13g2_decap_8
XFILLER_1_324 VDD VSS sg13g2_decap_8
XFILLER_78_58 VDD VSS sg13g2_fill_2
Xhold671 _4101_/Y VDD VSS _4963_/D sg13g2_dlygate4sd3_1
Xhold660 _4027_/Y VDD VSS _4956_/D sg13g2_dlygate4sd3_1
XFILLER_104_753 VDD VSS sg13g2_decap_8
XFILLER_2_869 VDD VSS sg13g2_decap_8
Xhold693 _4973_/Q VDD VSS _4201_/B sg13g2_dlygate4sd3_1
Xhold682 _2773_/Y VDD VSS _4937_/D sg13g2_dlygate4sd3_1
XFILLER_49_339 VDD VSS sg13g2_decap_8
XFILLER_77_637 VDD VSS sg13g2_decap_8
XFILLER_58_862 VDD VSS sg13g2_decap_8
XFILLER_76_136 VDD VSS sg13g2_decap_8
XFILLER_94_35 VDD VSS sg13g2_decap_8
XFILLER_73_810 VDD VSS sg13g2_decap_8
Xhold1360 _4653_/Q VDD VSS _3429_/A sg13g2_dlygate4sd3_1
XFILLER_94_68 VDD VSS sg13g2_decap_4
XFILLER_85_670 VDD VSS sg13g2_decap_8
XFILLER_84_180 VDD VSS sg13g2_decap_8
Xhold1371 _3855_/Y VDD VSS _4792_/D sg13g2_dlygate4sd3_1
Xhold1382 _4941_/Q VDD VSS _2783_/A sg13g2_dlygate4sd3_1
Xhold1393 _2470_/Y VDD VSS _4848_/D sg13g2_dlygate4sd3_1
XFILLER_17_247 VDD VSS sg13g2_decap_8
XFILLER_27_84 VDD VSS sg13g2_decap_8
XFILLER_27_95 VDD VSS sg13g2_fill_2
XFILLER_45_556 VDD VSS sg13g2_decap_8
XFILLER_45_567 VDD VSS sg13g2_fill_1
X_4431__495 VDD VSS _4431_/RESET_B sg13g2_tiehi
XFILLER_14_921 VDD VSS sg13g2_decap_4
XFILLER_32_217 VDD VSS sg13g2_decap_8
XFILLER_72_386 VDD VSS sg13g2_fill_2
XFILLER_41_784 VDD VSS sg13g2_decap_8
XFILLER_41_795 VDD VSS sg13g2_fill_2
XFILLER_43_72 VDD VSS sg13g2_decap_8
XFILLER_40_294 VDD VSS sg13g2_decap_4
XFILLER_57_7 VDD VSS sg13g2_decap_8
XFILLER_5_652 VDD VSS sg13g2_fill_1
XFILLER_4_77 VDD VSS sg13g2_decap_4
XFILLER_1_880 VDD VSS sg13g2_decap_8
X_3110_ _3110_/A0 _3142_/A _3110_/S _3110_/X VDD VSS sg13g2_mux2_1
XFILLER_83_607 VDD VSS sg13g2_fill_2
X_4090_ _4118_/S _4369_/Q _4090_/Y VDD VSS sg13g2_nor2_1
XFILLER_48_350 VDD VSS sg13g2_decap_8
XFILLER_55_309 VDD VSS sg13g2_decap_8
XFILLER_67_169 VDD VSS sg13g2_decap_8
X_3041_ _3552_/A1 _3066_/A1 _3056_/S _4467_/D VDD VSS sg13g2_mux2_1
XFILLER_36_534 VDD VSS sg13g2_fill_1
XFILLER_64_887 VDD VSS sg13g2_decap_4
XFILLER_75_191 VDD VSS sg13g2_decap_8
XFILLER_91_673 VDD VSS sg13g2_decap_8
XFILLER_63_386 VDD VSS sg13g2_decap_8
XFILLER_90_183 VDD VSS sg13g2_decap_8
X_3943_ _3954_/D _3944_/A _3944_/C VDD VSS sg13g2_nand2_1
X_3874_ VSS VDD _4800_/Q _3879_/D _3874_/Y _2473_/B sg13g2_a21oi_1
XFILLER_83_0 VDD VSS sg13g2_decap_8
X_2825_ _2825_/A0 _3087_/A0 _2848_/S _4262_/D VDD VSS sg13g2_mux2_1
X_2756_ _2756_/A _2756_/B _2756_/Y VDD VSS sg13g2_nor2_1
X_2687_ _4718_/Q _4719_/Q _2688_/D VDD VSS sg13g2_nor2_1
XFILLER_105_539 VDD VSS sg13g2_decap_8
X_4426_ _4426_/RESET_B VSS VDD _4426_/D _4426_/Q _4979_/CLK sg13g2_dfrbpq_1
XFILLER_99_762 VDD VSS sg13g2_fill_2
XFILLER_99_751 VDD VSS sg13g2_decap_8
XFILLER_100_200 VDD VSS sg13g2_decap_4
XFILLER_58_103 VDD VSS sg13g2_fill_2
XFILLER_59_615 VDD VSS sg13g2_decap_4
X_4357_ _4357_/RESET_B VSS VDD _4357_/D _4357_/Q clkload8/A sg13g2_dfrbpq_1
XFILLER_113_594 VDD VSS sg13g2_fill_1
XFILLER_58_147 VDD VSS sg13g2_fill_1
XFILLER_74_607 VDD VSS sg13g2_fill_2
X_4288_ _4288_/RESET_B VSS VDD _4288_/D _4288_/Q _4926_/CLK sg13g2_dfrbpq_1
X_3308_ _3337_/D _3329_/A _3413_/C VDD VSS sg13g2_nand2_1
XFILLER_86_445 VDD VSS sg13g2_decap_8
XFILLER_101_778 VDD VSS sg13g2_decap_4
XFILLER_73_106 VDD VSS sg13g2_decap_8
X_3239_ _2602_/Y _2603_/C _3232_/A _3239_/X VDD VSS sg13g2_a21o_1
XFILLER_104_56 VDD VSS sg13g2_decap_8
XFILLER_27_512 VDD VSS sg13g2_fill_1
XFILLER_39_372 VDD VSS sg13g2_decap_8
XFILLER_54_320 VDD VSS sg13g2_decap_8
XFILLER_55_854 VDD VSS sg13g2_decap_8
XFILLER_64_49 VDD VSS sg13g2_decap_8
XFILLER_82_673 VDD VSS sg13g2_decap_8
XFILLER_14_206 VDD VSS sg13g2_decap_8
XFILLER_27_589 VDD VSS sg13g2_decap_8
XFILLER_54_397 VDD VSS sg13g2_decap_8
XFILLER_70_824 VDD VSS sg13g2_decap_8
XFILLER_42_559 VDD VSS sg13g2_decap_8
Xfanout32 _2516_/Y _3144_/A VDD VSS sg13g2_buf_1
Xfanout43 _3852_/A _3837_/B1 VDD VSS sg13g2_buf_1
Xfanout54 _3443_/C _3473_/C VDD VSS sg13g2_buf_1
Xfanout65 _3142_/B _3128_/B VDD VSS sg13g2_buf_1
XFILLER_10_423 VDD VSS sg13g2_decap_8
XFILLER_50_581 VDD VSS sg13g2_decap_8
Xfanout76 _3033_/S _3029_/S VDD VSS sg13g2_buf_1
Xfanout87 fanout88/X _2975_/S VDD VSS sg13g2_buf_1
Xfanout98 _2903_/Y fanout98/X VDD VSS sg13g2_buf_1
XFILLER_10_467 VDD VSS sg13g2_decap_8
XFILLER_89_57 VDD VSS sg13g2_decap_4
XFILLER_1_121 VDD VSS sg13g2_decap_8
XFILLER_89_272 VDD VSS sg13g2_decap_8
XFILLER_37_309 VDD VSS sg13g2_decap_8
XFILLER_58_670 VDD VSS sg13g2_fill_1
XFILLER_77_489 VDD VSS sg13g2_decap_8
X_4355__371 VDD VSS _4355_/RESET_B sg13g2_tiehi
XFILLER_18_523 VDD VSS sg13g2_fill_1
XFILLER_18_534 VDD VSS sg13g2_decap_8
XFILLER_46_821 VDD VSS sg13g2_decap_4
XFILLER_57_180 VDD VSS sg13g2_fill_1
XFILLER_92_437 VDD VSS sg13g2_decap_8
Xhold1190 _3015_/X VDD VSS _4441_/D sg13g2_dlygate4sd3_1
XFILLER_45_397 VDD VSS sg13g2_fill_2
XFILLER_61_846 VDD VSS sg13g2_decap_4
XFILLER_54_60 VDD VSS sg13g2_decap_4
XFILLER_60_356 VDD VSS sg13g2_fill_2
XFILLER_14_784 VDD VSS sg13g2_decap_8
XFILLER_60_378 VDD VSS sg13g2_decap_8
XFILLER_9_221 VDD VSS sg13g2_decap_8
X_4362__364 VDD VSS _4362_/RESET_B sg13g2_tiehi
Xclkload13 clkload13/Y _4950_/CLK VDD VSS sg13g2_inv_2
Xclkload24 _4958_/CLK clkload24/X VDD VSS sg13g2_buf_8
Xclkload35 clkload35/Y _4824_/CLK VDD VSS sg13g2_inv_2
X_3590_ _4863_/Q _3595_/A _3590_/C _3590_/D _3593_/A VDD VSS sg13g2_nor4_1
X_2610_ _3258_/A _2611_/B _3258_/B _3263_/B VDD VSS sg13g2_nor3_1
XFILLER_9_287 VDD VSS sg13g2_decap_8
XFILLER_115_804 VDD VSS sg13g2_decap_8
X_2541_ _2541_/Y _2541_/A _2541_/B VDD VSS sg13g2_xnor2_1
XFILLER_5_471 VDD VSS sg13g2_decap_8
X_2472_ VDD _4854_/D _3128_/B VSS sg13g2_inv_1
XFILLER_102_509 VDD VSS sg13g2_fill_1
X_4211_ _4210_/Y VDD _4211_/Y VSS _4207_/Y _4209_/Y sg13g2_o21ai_1
X_4142_ _4144_/S _4142_/B _4142_/Y VDD VSS sg13g2_nor2_1
XFILLER_110_553 VDD VSS sg13g2_fill_1
XFILLER_56_629 VDD VSS sg13g2_decap_8
X_4073_ _4417_/Q _4442_/Q _4251_/S _4073_/X VDD VSS sg13g2_mux2_1
XFILLER_96_798 VDD VSS sg13g2_decap_8
XFILLER_37_843 VDD VSS sg13g2_decap_8
XFILLER_83_426 VDD VSS sg13g2_decap_4
XFILLER_83_448 VDD VSS sg13g2_decap_4
X_3024_ _3024_/A0 _4524_/Q _3029_/S _3024_/X VDD VSS sg13g2_mux2_1
XFILLER_64_651 VDD VSS sg13g2_decap_8
XFILLER_63_172 VDD VSS sg13g2_fill_2
XFILLER_51_334 VDD VSS sg13g2_fill_2
X_4975_ fanout306/X VSS VDD _4975_/D _4975_/Q _4975_/CLK sg13g2_dfrbpq_1
XFILLER_51_378 VDD VSS sg13g2_fill_2
X_3926_ VSS VDD _3925_/A _3923_/A _3926_/Y _3925_/Y sg13g2_a21oi_1
XFILLER_20_732 VDD VSS sg13g2_decap_4
XFILLER_20_754 VDD VSS sg13g2_decap_8
Xclkload7 VDD clkload7/Y clkload7/A VSS sg13g2_inv_1
X_3857_ hold851/X hold838/X _4856_/D _4794_/D VDD VSS sg13g2_mux2_1
X_3788_ _3807_/A _3788_/B _4774_/D VDD VSS sg13g2_and2_1
X_2808_ _2419_/A VDD _2809_/C VSS _3407_/A _2419_/D sg13g2_o21ai_1
X_2739_ _2739_/B _2739_/C _2739_/A _2742_/B VDD VSS sg13g2_nand3_1
XFILLER_114_870 VDD VSS sg13g2_decap_8
Xfanout200 _4187_/A _4186_/S VDD VSS sg13g2_buf_1
Xfanout211 hold1332/X _3688_/A VDD VSS sg13g2_buf_1
Xfanout222 _3033_/A1 _3109_/A0 VDD VSS sg13g2_buf_1
X_4409_ _4409_/RESET_B VSS VDD _4409_/D _4409_/Q _4974_/CLK sg13g2_dfrbpq_1
Xfanout233 hold896/X _3098_/A0 VDD VSS sg13g2_buf_1
Xfanout244 _3011_/A1 _3087_/A0 VDD VSS sg13g2_buf_1
Xfanout255 fanout256/X fanout255/X VDD VSS sg13g2_buf_1
XFILLER_87_754 VDD VSS sg13g2_decap_8
XFILLER_115_66 VDD VSS sg13g2_decap_8
Xfanout266 fanout267/X fanout266/X VDD VSS sg13g2_buf_1
Xfanout277 fanout278/X fanout277/X VDD VSS sg13g2_buf_1
Xfanout288 fanout291/X fanout288/X VDD VSS sg13g2_buf_1
Xfanout299 fanout300/X fanout299/X VDD VSS sg13g2_buf_1
XFILLER_43_802 VDD VSS sg13g2_decap_8
XFILLER_15_515 VDD VSS sg13g2_decap_8
XFILLER_42_312 VDD VSS sg13g2_decap_8
XFILLER_43_879 VDD VSS sg13g2_fill_1
XFILLER_23_570 VDD VSS sg13g2_fill_1
XFILLER_10_231 VDD VSS sg13g2_decap_8
XFILLER_24_96 VDD VSS sg13g2_decap_8
XFILLER_109_620 VDD VSS sg13g2_decap_8
XFILLER_11_787 VDD VSS sg13g2_fill_2
XFILLER_11_798 VDD VSS sg13g2_fill_1
XFILLER_108_141 VDD VSS sg13g2_fill_2
XFILLER_7_769 VDD VSS sg13g2_decap_8
XFILLER_109_686 VDD VSS sg13g2_decap_8
XFILLER_105_870 VDD VSS sg13g2_decap_8
XFILLER_105_881 VDD VSS sg13g2_fill_1
XFILLER_111_317 VDD VSS sg13g2_decap_8
XFILLER_77_264 VDD VSS sg13g2_decap_8
XFILLER_78_765 VDD VSS sg13g2_decap_8
XFILLER_1_56 VDD VSS sg13g2_decap_8
XFILLER_37_128 VDD VSS sg13g2_decap_8
XFILLER_65_437 VDD VSS sg13g2_decap_8
XFILLER_77_275 VDD VSS sg13g2_fill_2
XFILLER_92_201 VDD VSS sg13g2_decap_8
XFILLER_19_854 VDD VSS sg13g2_decap_8
XFILLER_1_67 VDD VSS sg13g2_fill_1
XFILLER_45_161 VDD VSS sg13g2_decap_8
XFILLER_61_610 VDD VSS sg13g2_decap_8
XFILLER_65_70 VDD VSS sg13g2_decap_8
XFILLER_61_643 VDD VSS sg13g2_decap_4
XFILLER_21_518 VDD VSS sg13g2_decap_8
XFILLER_33_367 VDD VSS sg13g2_decap_8
XFILLER_81_80 VDD VSS sg13g2_decap_4
X_4760_ fanout257/X VSS VDD _4760_/D _4760_/Q _4907_/CLK sg13g2_dfrbpq_1
X_4691_ fanout332/X VSS VDD _4691_/D _4691_/Q _4933_/CLK sg13g2_dfrbpq_1
X_3711_ _3710_/Y VDD _3711_/Y VSS _3706_/A _3709_/Y sg13g2_o21ai_1
X_3642_ _3642_/A _3642_/B _4740_/D VDD VSS sg13g2_nor2_1
XFILLER_115_612 VDD VSS sg13g2_decap_8
XFILLER_6_791 VDD VSS sg13g2_decap_8
X_3573_ _3590_/C _3582_/B _3590_/D _3576_/A VDD VSS sg13g2_nor3_1
XFILLER_46_0 VDD VSS sg13g2_decap_8
X_2524_ _3735_/A _3740_/A _3792_/B _2524_/D _3745_/C VDD VSS sg13g2_and4_1
XFILLER_114_155 VDD VSS sg13g2_decap_8
X_2455_ VSS VDD _4852_/D _3866_/A _3868_/A sg13g2_or2_1
XFILLER_102_328 VDD VSS sg13g2_decap_8
XFILLER_69_732 VDD VSS sg13g2_decap_8
X_2386_ _2386_/A _2386_/B _2386_/C _2386_/D _2387_/D VDD VSS sg13g2_nor4_1
XFILLER_68_242 VDD VSS sg13g2_decap_4
X_4125_ _2347_/A VDD _4125_/Y VSS _4205_/A1 _4447_/Q sg13g2_o21ai_1
XFILLER_28_117 VDD VSS sg13g2_decap_8
XFILLER_56_448 VDD VSS sg13g2_decap_8
XFILLER_84_724 VDD VSS sg13g2_decap_8
XFILLER_72_908 VDD VSS sg13g2_decap_8
XFILLER_83_256 VDD VSS sg13g2_decap_8
X_4056_ _4056_/Y _4078_/A _4056_/B VDD VSS sg13g2_nand2_1
XFILLER_36_150 VDD VSS sg13g2_decap_8
X_3007_ _3007_/A0 _3109_/A0 _3007_/S _3007_/X VDD VSS sg13g2_mux2_1
XFILLER_24_345 VDD VSS sg13g2_fill_2
XFILLER_36_172 VDD VSS sg13g2_fill_1
XFILLER_51_120 VDD VSS sg13g2_decap_8
XFILLER_51_153 VDD VSS sg13g2_fill_1
XFILLER_101_68 VDD VSS sg13g2_decap_8
XFILLER_51_197 VDD VSS sg13g2_fill_2
XFILLER_61_28 VDD VSS sg13g2_decap_8
X_4958_ fanout298/X VSS VDD _4958_/D _4958_/Q _4958_/CLK sg13g2_dfrbpq_1
XFILLER_20_540 VDD VSS sg13g2_fill_2
X_4889_ fanout309/X VSS VDD _4889_/D _4889_/Q _4894_/CLK sg13g2_dfrbpq_1
X_3909_ _4811_/Q _3918_/D _3910_/B VDD VSS sg13g2_and2_1
XFILLER_20_584 VDD VSS sg13g2_decap_8
X_4345__381 VDD VSS _4345_/RESET_B sg13g2_tiehi
XFILLER_106_601 VDD VSS sg13g2_decap_8
XFILLER_10_21 VDD VSS sg13g2_decap_8
XFILLER_4_739 VDD VSS sg13g2_decap_8
XFILLER_3_249 VDD VSS sg13g2_decap_8
XFILLER_105_166 VDD VSS sg13g2_decap_8
XFILLER_87_540 VDD VSS sg13g2_decap_8
XFILLER_86_14 VDD VSS sg13g2_decap_8
XFILLER_101_372 VDD VSS sg13g2_decap_8
XFILLER_19_85 VDD VSS sg13g2_decap_8
XFILLER_63_919 VDD VSS sg13g2_decap_8
X_4352__374 VDD VSS _4352_/RESET_B sg13g2_tiehi
XFILLER_28_662 VDD VSS sg13g2_decap_8
XFILLER_34_109 VDD VSS sg13g2_decap_8
XFILLER_74_278 VDD VSS sg13g2_fill_1
XFILLER_90_749 VDD VSS sg13g2_decap_8
XFILLER_27_172 VDD VSS sg13g2_decap_8
XFILLER_27_194 VDD VSS sg13g2_decap_8
XFILLER_15_356 VDD VSS sg13g2_decap_8
XFILLER_35_84 VDD VSS sg13g2_decap_4
XFILLER_43_665 VDD VSS sg13g2_decap_8
XFILLER_30_359 VDD VSS sg13g2_fill_2
XFILLER_51_50 VDD VSS sg13g2_decap_8
XFILLER_51_61 VDD VSS sg13g2_fill_1
XFILLER_109_461 VDD VSS sg13g2_decap_8
XFILLER_7_577 VDD VSS sg13g2_decap_8
XFILLER_98_805 VDD VSS sg13g2_decap_8
XFILLER_3_772 VDD VSS sg13g2_decap_8
XFILLER_112_648 VDD VSS sg13g2_decap_8
X_2240_ VDD _2240_/Y _3877_/A VSS sg13g2_inv_1
XFILLER_97_326 VDD VSS sg13g2_decap_8
XFILLER_38_404 VDD VSS sg13g2_decap_4
XFILLER_66_713 VDD VSS sg13g2_fill_2
XFILLER_78_540 VDD VSS sg13g2_decap_8
XFILLER_93_532 VDD VSS sg13g2_decap_8
XFILLER_19_640 VDD VSS sg13g2_decap_8
XFILLER_19_651 VDD VSS sg13g2_fill_2
XFILLER_66_779 VDD VSS sg13g2_fill_1
XFILLER_18_161 VDD VSS sg13g2_decap_4
XFILLER_25_109 VDD VSS sg13g2_decap_8
XFILLER_80_215 VDD VSS sg13g2_decap_8
XFILLER_80_226 VDD VSS sg13g2_fill_2
XFILLER_33_142 VDD VSS sg13g2_decap_8
XFILLER_34_687 VDD VSS sg13g2_decap_8
XFILLER_61_462 VDD VSS sg13g2_decap_4
XFILLER_21_315 VDD VSS sg13g2_decap_8
XFILLER_22_838 VDD VSS sg13g2_decap_8
XFILLER_61_484 VDD VSS sg13g2_decap_8
X_4812_ fanout314/X VSS VDD _4812_/D _4812_/Q _4824_/CLK sg13g2_dfrbpq_1
X_4743_ fanout272/X VSS VDD _4743_/D _4743_/Q _4745_/CLK sg13g2_dfrbpq_1
XFILLER_30_871 VDD VSS sg13g2_decap_4
XFILLER_30_893 VDD VSS sg13g2_decap_4
X_4674_ fanout254/X VSS VDD _4674_/D _4674_/Q clkload4/A sg13g2_dfrbpq_1
X_3625_ _3625_/A0 _3625_/A1 _3653_/S _4737_/D VDD VSS sg13g2_mux2_1
XFILLER_115_420 VDD VSS sg13g2_fill_2
X_3556_ _3556_/A _3556_/B _3558_/B VDD VSS sg13g2_nor2_1
X_2507_ _3162_/B _2508_/A _2508_/D VDD VSS sg13g2_nand2_1
X_3487_ _3489_/B _3490_/S _3487_/A _3487_/Y VDD VSS sg13g2_nand3_1
X_2438_ _2438_/B _2438_/C _2809_/A _2438_/Y VDD VSS sg13g2_nand3_1
XFILLER_97_871 VDD VSS sg13g2_decap_8
XFILLER_29_437 VDD VSS sg13g2_decap_8
XFILLER_57_746 VDD VSS sg13g2_decap_8
XFILLER_69_584 VDD VSS sg13g2_decap_8
X_2369_ _2369_/Y _4660_/Q _4652_/Q VDD VSS sg13g2_nand2_1
XFILLER_96_370 VDD VSS sg13g2_decap_8
XFILLER_57_757 VDD VSS sg13g2_fill_1
XFILLER_84_554 VDD VSS sg13g2_decap_8
XFILLER_84_565 VDD VSS sg13g2_fill_2
X_4108_ _4078_/A VDD _4108_/Y VSS _2348_/A _4102_/X sg13g2_o21ai_1
XFILLER_72_716 VDD VSS sg13g2_decap_8
X_4039_ _4172_/S1 VDD _4039_/Y VSS _4241_/A1 _4439_/Q sg13g2_o21ai_1
XFILLER_112_56 VDD VSS sg13g2_fill_1
XFILLER_24_131 VDD VSS sg13g2_decap_8
XFILLER_52_484 VDD VSS sg13g2_fill_1
XFILLER_40_668 VDD VSS sg13g2_decap_8
XFILLER_8_308 VDD VSS sg13g2_fill_2
XFILLER_21_871 VDD VSS sg13g2_decap_8
XFILLER_106_420 VDD VSS sg13g2_decap_8
XFILLER_0_753 VDD VSS sg13g2_decap_8
XFILLER_75_510 VDD VSS sg13g2_fill_1
XFILLER_90_502 VDD VSS sg13g2_decap_4
XFILLER_16_632 VDD VSS sg13g2_decap_8
XFILLER_16_643 VDD VSS sg13g2_fill_2
XFILLER_16_698 VDD VSS sg13g2_decap_8
XFILLER_70_270 VDD VSS sg13g2_decap_8
XFILLER_71_793 VDD VSS sg13g2_decap_8
XFILLER_87_7 VDD VSS sg13g2_decap_8
XFILLER_116_228 VDD VSS sg13g2_decap_8
XFILLER_7_363 VDD VSS sg13g2_decap_8
XFILLER_8_897 VDD VSS sg13g2_decap_8
XFILLER_109_280 VDD VSS sg13g2_fill_2
X_4390_ _4390_/RESET_B VSS VDD _4390_/D _4390_/Q _4964_/CLK sg13g2_dfrbpq_1
X_3410_ _3493_/B _3410_/C _3493_/A _3425_/B VDD VSS sg13g2_nand3_1
XFILLER_113_913 VDD VSS sg13g2_decap_8
XFILLER_113_924 VDD VSS sg13g2_fill_2
X_3341_ _3378_/C _3489_/C _3489_/D _3327_/B _3327_/A VDD VSS sg13g2_a22oi_1
XFILLER_98_613 VDD VSS sg13g2_decap_8
XFILLER_112_434 VDD VSS sg13g2_decap_8
X_3272_ _3281_/A _3272_/B _4614_/D VDD VSS sg13g2_nor2_1
XFILLER_98_679 VDD VSS sg13g2_decap_8
XFILLER_66_521 VDD VSS sg13g2_fill_2
Xhold1008 _3023_/X VDD VSS _4449_/D sg13g2_dlygate4sd3_1
Xhold1019 _4489_/Q VDD VSS _3063_/A1 sg13g2_dlygate4sd3_1
XFILLER_38_223 VDD VSS sg13g2_decap_8
XFILLER_38_245 VDD VSS sg13g2_decap_8
XFILLER_94_863 VDD VSS sg13g2_decap_8
XFILLER_38_289 VDD VSS sg13g2_decap_8
XFILLER_66_598 VDD VSS sg13g2_fill_2
XFILLER_81_502 VDD VSS sg13g2_fill_2
X_4335__391 VDD VSS _4335_/RESET_B sg13g2_tiehi
XFILLER_19_481 VDD VSS sg13g2_fill_1
XFILLER_62_793 VDD VSS sg13g2_decap_8
XFILLER_22_668 VDD VSS sg13g2_decap_8
X_2987_ hold839/X _3089_/A0 _3007_/S _2987_/X VDD VSS sg13g2_mux2_1
X_4726_ fanout332/X VSS VDD _4726_/D _4726_/Q _4933_/CLK sg13g2_dfrbpq_1
X_4657_ fanout254/X VSS VDD _4657_/D _4657_/Q _4673_/CLK sg13g2_dfrbpq_1
XFILLER_107_239 VDD VSS sg13g2_decap_8
XFILLER_116_740 VDD VSS sg13g2_decap_8
Xhold820 _2997_/X VDD VSS _4424_/D sg13g2_dlygate4sd3_1
X_4342__384 VDD VSS _4342_/RESET_B sg13g2_tiehi
X_3608_ _3608_/A _3608_/B _3608_/Y VDD VSS sg13g2_nor2_1
XFILLER_103_401 VDD VSS sg13g2_decap_8
XFILLER_104_924 VDD VSS sg13g2_fill_2
XFILLER_115_250 VDD VSS sg13g2_decap_8
XFILLER_1_506 VDD VSS sg13g2_decap_4
Xhold864 _2934_/X VDD VSS _4364_/D sg13g2_dlygate4sd3_1
Xhold853 _2882_/X VDD VSS _4315_/D sg13g2_dlygate4sd3_1
Xhold842 _3112_/X VDD VSS _4536_/D sg13g2_dlygate4sd3_1
Xhold831 _4413_/Q VDD VSS _4029_/B sg13g2_dlygate4sd3_1
X_4588_ fanout280/X VSS VDD _4588_/D _4588_/Q _4946_/CLK sg13g2_dfrbpq_1
Xhold897 _4971_/Q VDD VSS _4179_/B sg13g2_dlygate4sd3_1
Xhold886 _3813_/Y VDD VSS _4778_/D sg13g2_dlygate4sd3_1
Xhold875 _3126_/X VDD VSS _4550_/D sg13g2_dlygate4sd3_1
X_3539_ _3539_/A0 _3539_/A1 _3553_/S _4701_/D VDD VSS sg13g2_mux2_1
XFILLER_107_78 VDD VSS sg13g2_decap_4
XFILLER_29_212 VDD VSS sg13g2_decap_8
XFILLER_67_49 VDD VSS sg13g2_decap_8
XFILLER_57_543 VDD VSS sg13g2_decap_8
Xhold1520 _3224_/X VDD VSS _3225_/B sg13g2_dlygate4sd3_1
Xhold1531 _4729_/Q VDD VSS _3614_/A sg13g2_dlygate4sd3_1
Xhold1542 _4904_/Q VDD VSS _3728_/A sg13g2_dlygate4sd3_1
Xhold1553 _4873_/Q VDD VSS _2537_/C sg13g2_dlygate4sd3_1
XFILLER_45_716 VDD VSS sg13g2_decap_8
XFILLER_72_502 VDD VSS sg13g2_decap_8
Xhold1564 _4768_/Q VDD VSS _3768_/A sg13g2_dlygate4sd3_1
Xhold1575 _4720_/Q VDD VSS _3580_/A sg13g2_dlygate4sd3_1
Xhold1586 _3271_/Y VDD VSS _3272_/B sg13g2_dlygate4sd3_1
XFILLER_85_885 VDD VSS sg13g2_decap_8
XFILLER_29_289 VDD VSS sg13g2_decap_8
XFILLER_44_215 VDD VSS sg13g2_decap_8
XFILLER_84_395 VDD VSS sg13g2_decap_8
Xhold1597 _4735_/Q VDD VSS _3623_/A0 sg13g2_dlygate4sd3_1
XFILLER_12_101 VDD VSS sg13g2_decap_8
XFILLER_13_613 VDD VSS sg13g2_decap_8
XFILLER_40_476 VDD VSS sg13g2_decap_8
XFILLER_8_105 VDD VSS sg13g2_decap_8
XFILLER_32_63 VDD VSS sg13g2_decap_8
XFILLER_32_85 VDD VSS sg13g2_decap_8
XFILLER_5_823 VDD VSS sg13g2_decap_8
XFILLER_113_0 VDD VSS sg13g2_decap_8
XFILLER_110_916 VDD VSS sg13g2_decap_8
XFILLER_67_307 VDD VSS sg13g2_decap_8
XFILLER_0_550 VDD VSS sg13g2_decap_8
XFILLER_48_510 VDD VSS sg13g2_decap_8
XFILLER_79_167 VDD VSS sg13g2_decap_8
XFILLER_76_852 VDD VSS sg13g2_fill_1
XFILLER_88_690 VDD VSS sg13g2_decap_8
XFILLER_48_587 VDD VSS sg13g2_decap_8
XFILLER_57_82 VDD VSS sg13g2_decap_8
XFILLER_75_373 VDD VSS sg13g2_decap_4
XFILLER_35_215 VDD VSS sg13g2_decap_8
XFILLER_90_321 VDD VSS sg13g2_decap_8
XFILLER_35_248 VDD VSS sg13g2_decap_4
XFILLER_90_354 VDD VSS sg13g2_decap_8
XFILLER_50_218 VDD VSS sg13g2_decap_8
XFILLER_73_70 VDD VSS sg13g2_decap_8
X_2910_ hold960/X _3092_/A0 _2928_/S _4342_/D VDD VSS sg13g2_mux2_1
X_3890_ VSS VDD _2244_/Y _3889_/Y _3890_/Y _3888_/Y sg13g2_a21oi_1
X_2841_ _2841_/A0 _3103_/A0 _2842_/S _2841_/X VDD VSS sg13g2_mux2_1
X_2772_ _2773_/B _3528_/A _2774_/B VDD VSS sg13g2_nand2_1
X_4511_ fanout284/X VSS VDD _4511_/D _4511_/Q _4559_/CLK sg13g2_dfrbpq_1
X_4442_ _4442_/RESET_B VSS VDD _4442_/D _4442_/Q _4959_/CLK sg13g2_dfrbpq_1
XFILLER_99_900 VDD VSS sg13g2_fill_1
X_4373_ _4373_/RESET_B VSS VDD _4373_/D _4373_/Q _4975_/CLK sg13g2_dfrbpq_1
X_3324_ _3399_/C _4784_/Q _4783_/Q VDD VSS sg13g2_nand2_1
XFILLER_98_454 VDD VSS sg13g2_decap_8
X_3255_ _3253_/B _2609_/B _2609_/C _3255_/X VDD VSS sg13g2_a21o_1
XFILLER_100_437 VDD VSS sg13g2_fill_2
XFILLER_39_543 VDD VSS sg13g2_fill_1
XFILLER_26_204 VDD VSS sg13g2_decap_8
XFILLER_39_554 VDD VSS sg13g2_decap_4
XFILLER_67_896 VDD VSS sg13g2_decap_4
XFILLER_82_800 VDD VSS sg13g2_decap_8
X_3186_ _3186_/B _3186_/A _3186_/X VDD VSS sg13g2_xor2_1
XFILLER_54_546 VDD VSS sg13g2_decap_8
XFILLER_81_343 VDD VSS sg13g2_decap_8
XFILLER_81_354 VDD VSS sg13g2_fill_2
XFILLER_93_192 VDD VSS sg13g2_decap_8
XFILLER_22_421 VDD VSS sg13g2_decap_8
XFILLER_34_292 VDD VSS sg13g2_decap_4
XFILLER_22_454 VDD VSS sg13g2_decap_8
XFILLER_5_108 VDD VSS sg13g2_decap_8
X_4709_ fanout307/X VSS VDD _4709_/D _4709_/Q _4975_/CLK sg13g2_dfrbpq_1
XFILLER_104_710 VDD VSS sg13g2_decap_8
XFILLER_1_303 VDD VSS sg13g2_decap_8
XFILLER_2_848 VDD VSS sg13g2_decap_8
XFILLER_78_37 VDD VSS sg13g2_decap_8
Xhold672 _4557_/Q VDD VSS _3138_/A sg13g2_dlygate4sd3_1
Xhold661 _4907_/Q VDD VSS _2414_/C sg13g2_dlygate4sd3_1
Xhold650 _4193_/Y VDD VSS _4972_/D sg13g2_dlygate4sd3_1
XFILLER_89_432 VDD VSS sg13g2_decap_8
Xhold694 _4202_/Y VDD VSS _4973_/D sg13g2_dlygate4sd3_1
Xhold683 _4962_/Q VDD VSS _4088_/B sg13g2_dlygate4sd3_1
XFILLER_103_253 VDD VSS sg13g2_decap_8
XFILLER_77_616 VDD VSS sg13g2_decap_8
XFILLER_89_487 VDD VSS sg13g2_decap_8
XFILLER_94_14 VDD VSS sg13g2_decap_8
XFILLER_92_608 VDD VSS sg13g2_decap_4
XFILLER_18_705 VDD VSS sg13g2_decap_8
Xhold1350 _4824_/Q VDD VSS _2247_/A sg13g2_dlygate4sd3_1
Xhold1361 _3430_/Y VDD VSS _4652_/D sg13g2_dlygate4sd3_1
XFILLER_17_226 VDD VSS sg13g2_decap_8
XFILLER_27_63 VDD VSS sg13g2_decap_8
XFILLER_45_535 VDD VSS sg13g2_decap_8
XFILLER_73_822 VDD VSS sg13g2_decap_4
Xhold1372 _4560_/Q VDD VSS _3147_/A sg13g2_dlygate4sd3_1
Xhold1383 _2783_/X VDD VSS _2784_/B sg13g2_dlygate4sd3_1
Xhold1394 _4773_/Q VDD VSS _3850_/A sg13g2_dlygate4sd3_1
XFILLER_14_900 VDD VSS sg13g2_decap_8
XFILLER_73_877 VDD VSS sg13g2_decap_8
XFILLER_26_793 VDD VSS sg13g2_fill_1
XFILLER_13_421 VDD VSS sg13g2_decap_8
XFILLER_41_763 VDD VSS sg13g2_decap_8
XFILLER_13_487 VDD VSS sg13g2_decap_8
XFILLER_9_436 VDD VSS sg13g2_decap_8
XFILLER_99_207 VDD VSS sg13g2_fill_1
XFILLER_107_592 VDD VSS sg13g2_decap_8
XFILLER_5_697 VDD VSS sg13g2_decap_8
XFILLER_4_56 VDD VSS sg13g2_decap_8
XFILLER_4_67 VDD VSS sg13g2_fill_2
XFILLER_4_89 VDD VSS sg13g2_fill_2
XFILLER_68_616 VDD VSS sg13g2_fill_2
XFILLER_68_81 VDD VSS sg13g2_decap_8
XFILLER_95_402 VDD VSS sg13g2_fill_1
XFILLER_95_435 VDD VSS sg13g2_decap_4
XFILLER_49_885 VDD VSS sg13g2_decap_8
X_3040_ _4466_/Q hold796/X _3051_/S _3040_/X VDD VSS sg13g2_mux2_1
XFILLER_75_170 VDD VSS sg13g2_decap_8
XFILLER_76_693 VDD VSS sg13g2_decap_8
XFILLER_36_579 VDD VSS sg13g2_decap_8
XFILLER_63_343 VDD VSS sg13g2_decap_8
XFILLER_63_354 VDD VSS sg13g2_fill_1
XFILLER_64_866 VDD VSS sg13g2_decap_4
XFILLER_91_652 VDD VSS sg13g2_decap_8
XFILLER_23_229 VDD VSS sg13g2_decap_8
XFILLER_63_365 VDD VSS sg13g2_decap_4
X_4332__394 VDD VSS _4332_/RESET_B sg13g2_tiehi
XFILLER_16_292 VDD VSS sg13g2_decap_8
XFILLER_32_730 VDD VSS sg13g2_fill_1
X_3942_ VSS VDD _3944_/A _3938_/Y _3942_/Y _3941_/Y sg13g2_a21oi_1
XFILLER_20_925 VDD VSS sg13g2_fill_1
XFILLER_31_240 VDD VSS sg13g2_fill_1
X_3873_ _3873_/Y _3877_/B _3911_/B VDD VSS sg13g2_nand2_1
XFILLER_31_284 VDD VSS sg13g2_decap_8
XFILLER_31_295 VDD VSS sg13g2_fill_1
X_2824_ _2824_/A0 _3086_/A0 _2848_/S _4261_/D VDD VSS sg13g2_mux2_1
XFILLER_76_0 VDD VSS sg13g2_decap_8
X_2755_ VDD _4954_/D _2755_/A VSS sg13g2_inv_1
XFILLER_8_491 VDD VSS sg13g2_decap_4
X_2686_ _2686_/B _4728_/Q _4724_/Q _2689_/C VDD VSS sg13g2_nand3_1
X_4425_ _4425_/RESET_B VSS VDD _4425_/D _4425_/Q _4977_/CLK sg13g2_dfrbpq_1
XFILLER_113_540 VDD VSS sg13g2_decap_8
X_4356_ _4356_/RESET_B VSS VDD _4356_/D _4356_/Q _4976_/CLK sg13g2_dfrbpq_1
XFILLER_87_914 VDD VSS sg13g2_decap_8
XFILLER_101_713 VDD VSS sg13g2_decap_8
XFILLER_58_115 VDD VSS sg13g2_fill_2
X_3307_ _3378_/B _3394_/A _3307_/B VDD VSS sg13g2_nand2_1
XFILLER_98_273 VDD VSS sg13g2_decap_4
XFILLER_87_925 VDD VSS sg13g2_fill_1
XFILLER_86_402 VDD VSS sg13g2_fill_1
XFILLER_101_757 VDD VSS sg13g2_decap_8
X_4287_ _4287_/RESET_B VSS VDD _4287_/D _4287_/Q _4559_/CLK sg13g2_dfrbpq_1
XFILLER_39_362 VDD VSS sg13g2_decap_4
X_3238_ VSS VDD hold983/X _3237_/Y _3238_/Y _3192_/X sg13g2_a21oi_1
XFILLER_104_79 VDD VSS sg13g2_fill_1
XFILLER_27_524 VDD VSS sg13g2_fill_1
XFILLER_66_170 VDD VSS sg13g2_decap_8
X_3169_ _3169_/B _3169_/A _3170_/B VDD VSS sg13g2_xor2_1
XFILLER_64_28 VDD VSS sg13g2_decap_8
XFILLER_70_803 VDD VSS sg13g2_decap_8
XFILLER_82_652 VDD VSS sg13g2_decap_8
XFILLER_42_516 VDD VSS sg13g2_decap_8
XFILLER_42_527 VDD VSS sg13g2_fill_1
XFILLER_54_376 VDD VSS sg13g2_decap_8
Xfanout22 _3279_/A _3289_/A VDD VSS sg13g2_buf_1
XFILLER_10_402 VDD VSS sg13g2_decap_8
XFILLER_23_763 VDD VSS sg13g2_fill_1
XFILLER_50_560 VDD VSS sg13g2_decap_8
Xfanout33 _2516_/Y _3179_/B1 VDD VSS sg13g2_buf_1
Xfanout44 _3807_/Y _3852_/A VDD VSS sg13g2_buf_1
Xfanout55 _3444_/A2 _3443_/C VDD VSS sg13g2_buf_1
XFILLER_13_21 VDD VSS sg13g2_decap_4
XFILLER_22_262 VDD VSS sg13g2_decap_4
XFILLER_7_907 VDD VSS sg13g2_decap_8
XFILLER_80_49 VDD VSS sg13g2_decap_8
Xfanout66 fanout67/X _3142_/B VDD VSS sg13g2_buf_1
Xfanout77 _3028_/S _3033_/S VDD VSS sg13g2_buf_1
Xfanout88 _2956_/Y fanout88/X VDD VSS sg13g2_buf_1
Xfanout99 fanout99/A _2900_/S VDD VSS sg13g2_buf_1
XFILLER_13_43 VDD VSS sg13g2_fill_2
XFILLER_108_334 VDD VSS sg13g2_decap_8
XFILLER_89_36 VDD VSS sg13g2_decap_8
XFILLER_108_389 VDD VSS sg13g2_decap_8
XFILLER_1_100 VDD VSS sg13g2_decap_8
XFILLER_2_601 VDD VSS sg13g2_decap_8
XFILLER_104_551 VDD VSS sg13g2_decap_8
XFILLER_89_251 VDD VSS sg13g2_decap_8
XFILLER_49_137 VDD VSS sg13g2_fill_2
XFILLER_77_424 VDD VSS sg13g2_fill_2
XFILLER_93_906 VDD VSS sg13g2_decap_8
XFILLER_89_295 VDD VSS sg13g2_fill_1
XFILLER_77_468 VDD VSS sg13g2_decap_8
XFILLER_38_84 VDD VSS sg13g2_fill_2
XFILLER_46_855 VDD VSS sg13g2_decap_8
XFILLER_73_652 VDD VSS sg13g2_decap_8
Xhold1180 _2973_/X VDD VSS _4402_/D sg13g2_dlygate4sd3_1
Xhold1191 _4400_/Q VDD VSS _2971_/A0 sg13g2_dlygate4sd3_1
XFILLER_72_151 VDD VSS sg13g2_decap_8
XFILLER_13_240 VDD VSS sg13g2_decap_4
XFILLER_14_763 VDD VSS sg13g2_decap_8
XFILLER_41_582 VDD VSS sg13g2_decap_4
Xclkload14 _4619_/CLK clkload14/X VDD VSS sg13g2_buf_8
Xclkload25 clkload25/Y _4884_/CLK VDD VSS sg13g2_inv_2
Xclkload36 VDD clkload36/Y _4929_/CLK VSS sg13g2_inv_1
X_2540_ _2540_/A _2540_/B _4873_/Q _2541_/A _2546_/D VDD VSS sg13g2_and4_1
XFILLER_115_849 VDD VSS sg13g2_decap_8
X_2471_ _3868_/A _3232_/A _2471_/Y VDD VSS _3866_/A sg13g2_nand3b_1
X_4210_ _4210_/Y _4210_/B _4236_/B1 VDD VSS sg13g2_nand2b_1
XFILLER_69_925 VDD VSS sg13g2_fill_1
XFILLER_96_711 VDD VSS sg13g2_decap_8
X_4141_ _4144_/S _4141_/A0 _4299_/Q _4324_/Q _4349_/Q _4232_/B1 _4141_/X VDD VSS sg13g2_mux4_1
XFILLER_56_608 VDD VSS sg13g2_decap_8
X_4072_ _4071_/Y VDD _4078_/B VSS _4068_/Y _4069_/Y sg13g2_o21ai_1
XFILLER_96_777 VDD VSS sg13g2_decap_8
XFILLER_95_254 VDD VSS sg13g2_decap_8
XFILLER_37_822 VDD VSS sg13g2_decap_8
X_3023_ _4143_/A2 _3023_/A1 _3029_/S _3023_/X VDD VSS sg13g2_mux2_1
XFILLER_48_192 VDD VSS sg13g2_decap_8
XFILLER_24_527 VDD VSS sg13g2_decap_8
XFILLER_36_398 VDD VSS sg13g2_decap_8
X_4974_ fanout305/X VSS VDD _4974_/D _4974_/Q _4974_/CLK sg13g2_dfrbpq_1
X_3925_ _3925_/A _3925_/B _3925_/Y VDD VSS sg13g2_nor2_1
XFILLER_20_711 VDD VSS sg13g2_decap_8
Xclkload8 VDD clkload8/Y clkload8/A VSS sg13g2_inv_1
X_3856_ _3807_/C _3856_/A1 _4903_/D _3856_/X VDD VSS sg13g2_a21o_1
X_3787_ _3785_/A _3850_/A _3787_/B1 _3787_/X VDD VSS sg13g2_a21o_1
X_2807_ _2807_/A _2807_/B _2807_/C _4917_/D VDD VSS sg13g2_nor3_1
X_2738_ VSS VDD _4948_/Q _2739_/C _2738_/Y _2739_/B sg13g2_a21oi_1
XFILLER_105_326 VDD VSS sg13g2_decap_4
XFILLER_59_28 VDD VSS sg13g2_fill_2
X_4408_ _4408_/RESET_B VSS VDD _4408_/D _4408_/Q _4977_/CLK sg13g2_dfrbpq_1
X_2669_ _2670_/C _4684_/Q _4699_/Q VDD VSS sg13g2_nand2_1
Xfanout201 _4187_/A _4251_/S VDD VSS sg13g2_buf_1
Xfanout212 _4738_/Q _3694_/A VDD VSS sg13g2_buf_1
Xfanout223 _3108_/A0 _3032_/A1 VDD VSS sg13g2_buf_1
X_4417__509 VDD VSS _4417_/RESET_B sg13g2_tiehi
XFILLER_115_45 VDD VSS sg13g2_decap_8
Xfanout234 _4521_/Q _3021_/A1 VDD VSS sg13g2_buf_1
Xfanout245 hold798/X _3086_/A0 VDD VSS sg13g2_buf_1
Xfanout256 fanout295/X fanout256/X VDD VSS sg13g2_buf_1
X_4339_ _4339_/RESET_B VSS VDD _4339_/D _4339_/Q clkload9/A sg13g2_dfrbpq_1
XFILLER_99_593 VDD VSS sg13g2_decap_8
XFILLER_87_733 VDD VSS sg13g2_decap_8
XFILLER_86_232 VDD VSS sg13g2_decap_8
XFILLER_47_608 VDD VSS sg13g2_fill_2
Xfanout267 fanout295/X fanout267/X VDD VSS sg13g2_buf_1
Xfanout278 fanout294/X fanout278/X VDD VSS sg13g2_buf_1
Xfanout289 fanout290/X fanout289/X VDD VSS sg13g2_buf_1
XFILLER_87_788 VDD VSS sg13g2_fill_1
XFILLER_86_243 VDD VSS sg13g2_fill_1
XFILLER_115_89 VDD VSS sg13g2_decap_8
XFILLER_46_129 VDD VSS sg13g2_decap_8
XFILLER_28_866 VDD VSS sg13g2_decap_8
XFILLER_67_490 VDD VSS sg13g2_decap_8
XFILLER_43_858 VDD VSS sg13g2_decap_8
XFILLER_54_184 VDD VSS sg13g2_decap_8
XFILLER_11_700 VDD VSS sg13g2_decap_8
XFILLER_70_688 VDD VSS sg13g2_decap_8
XFILLER_11_733 VDD VSS sg13g2_fill_1
XFILLER_24_64 VDD VSS sg13g2_decap_8
XFILLER_11_766 VDD VSS sg13g2_decap_8
XFILLER_7_715 VDD VSS sg13g2_decap_8
XFILLER_7_748 VDD VSS sg13g2_decap_8
XFILLER_108_120 VDD VSS sg13g2_decap_8
XFILLER_109_665 VDD VSS sg13g2_fill_2
XFILLER_10_287 VDD VSS sg13g2_decap_8
XFILLER_40_41 VDD VSS sg13g2_decap_8
XFILLER_6_0 VDD VSS sg13g2_decap_4
XFILLER_2_486 VDD VSS sg13g2_fill_1
XFILLER_77_243 VDD VSS sg13g2_decap_8
XFILLER_78_788 VDD VSS sg13g2_decap_8
XFILLER_1_35 VDD VSS sg13g2_decap_8
XFILLER_77_287 VDD VSS sg13g2_decap_4
XFILLER_92_224 VDD VSS sg13g2_fill_1
XFILLER_1_79 VDD VSS sg13g2_decap_8
Xclkbuf_leaf_57_clk clkbuf_4_2_0_clk/X _4926_/CLK VDD VSS sg13g2_buf_8
XFILLER_93_769 VDD VSS sg13g2_decap_8
XFILLER_45_151 VDD VSS sg13g2_decap_4
XFILLER_73_460 VDD VSS sg13g2_decap_8
XFILLER_18_398 VDD VSS sg13g2_decap_8
XFILLER_33_346 VDD VSS sg13g2_decap_8
XFILLER_34_858 VDD VSS sg13g2_decap_8
XFILLER_61_633 VDD VSS sg13g2_decap_4
XFILLER_60_165 VDD VSS sg13g2_decap_8
X_3710_ VSS VDD _3706_/X _3707_/Y _3710_/Y _3719_/A sg13g2_a21oi_1
X_4690_ fanout332/X VSS VDD _4690_/D _4690_/Q _4933_/CLK sg13g2_dfrbpq_1
X_3641_ _3643_/B VDD _3642_/B VSS _3626_/Y _3633_/B sg13g2_o21ai_1
X_3572_ _3590_/D _3572_/A _3592_/B VDD VSS sg13g2_nand2_1
XFILLER_6_770 VDD VSS sg13g2_decap_8
X_2523_ _3792_/B _4758_/Q _3735_/A _3740_/B VDD VSS sg13g2_nand3_1
XFILLER_114_145 VDD VSS sg13g2_fill_1
XFILLER_102_307 VDD VSS sg13g2_decap_8
X_2454_ _2488_/A _3868_/B _3866_/A VDD VSS sg13g2_nor2b_1
XFILLER_39_0 VDD VSS sg13g2_decap_8
X_2385_ _2369_/Y VDD _2386_/D VSS _4659_/Q _4651_/Q sg13g2_o21ai_1
XFILLER_57_917 VDD VSS sg13g2_decap_8
X_4124_ _4231_/A _4422_/Q _4124_/Y VDD VSS sg13g2_nor2_1
XFILLER_110_384 VDD VSS sg13g2_decap_8
XFILLER_56_427 VDD VSS sg13g2_decap_8
XFILLER_68_287 VDD VSS sg13g2_decap_8
Xinput1 ir_in input1/X VDD VSS sg13g2_buf_1
Xclkbuf_leaf_48_clk clkbuf_4_10_0_clk/X _4877_/CLK VDD VSS sg13g2_buf_8
X_4055_ VSS VDD _4226_/S1 _4051_/X _4055_/Y _4054_/Y sg13g2_a21oi_1
XFILLER_25_814 VDD VSS sg13g2_decap_8
XFILLER_37_674 VDD VSS sg13g2_decap_8
XFILLER_52_611 VDD VSS sg13g2_fill_1
X_3006_ _3006_/A0 _3032_/A1 _3007_/S _4433_/D VDD VSS sg13g2_mux2_1
XFILLER_101_14 VDD VSS sg13g2_decap_8
XFILLER_52_633 VDD VSS sg13g2_decap_8
XFILLER_64_493 VDD VSS sg13g2_decap_8
XFILLER_101_47 VDD VSS sg13g2_decap_8
XFILLER_12_508 VDD VSS sg13g2_fill_1
XFILLER_12_519 VDD VSS sg13g2_decap_8
X_4957_ fanout267/X VSS VDD _4957_/D _4957_/Q clkload9/A sg13g2_dfrbpq_1
XFILLER_32_390 VDD VSS sg13g2_decap_8
X_4888_ fanout309/X VSS VDD _4888_/D _4888_/Q _4894_/CLK sg13g2_dfrbpq_1
X_3908_ _3904_/Y _3907_/A _3907_/Y _3908_/X VDD VSS sg13g2_a21o_1
X_3839_ _3848_/A VDD _3839_/Y VSS _3839_/A1 _3838_/Y sg13g2_o21ai_1
XFILLER_4_718 VDD VSS sg13g2_decap_8
XFILLER_10_33 VDD VSS sg13g2_fill_2
XFILLER_105_156 VDD VSS sg13g2_fill_1
XFILLER_10_77 VDD VSS sg13g2_decap_4
XFILLER_102_863 VDD VSS sg13g2_decap_8
XFILLER_102_874 VDD VSS sg13g2_fill_1
XFILLER_48_906 VDD VSS sg13g2_decap_8
XFILLER_86_59 VDD VSS sg13g2_decap_8
XFILLER_101_351 VDD VSS sg13g2_decap_8
XFILLER_19_64 VDD VSS sg13g2_decap_8
XFILLER_28_641 VDD VSS sg13g2_decap_8
XFILLER_63_909 VDD VSS sg13g2_fill_1
Xclkbuf_leaf_39_clk clkbuf_4_3_0_clk/X _4959_/CLK VDD VSS sg13g2_buf_8
XFILLER_16_825 VDD VSS sg13g2_decap_8
XFILLER_42_121 VDD VSS sg13g2_decap_8
XFILLER_43_644 VDD VSS sg13g2_decap_8
XFILLER_82_290 VDD VSS sg13g2_decap_8
XFILLER_35_63 VDD VSS sg13g2_decap_8
XFILLER_15_379 VDD VSS sg13g2_decap_4
XFILLER_31_839 VDD VSS sg13g2_decap_8
XFILLER_70_485 VDD VSS sg13g2_decap_8
XFILLER_11_530 VDD VSS sg13g2_decap_8
XFILLER_30_338 VDD VSS sg13g2_decap_8
XFILLER_7_523 VDD VSS sg13g2_fill_1
XFILLER_109_440 VDD VSS sg13g2_decap_8
XFILLER_7_556 VDD VSS sg13g2_decap_8
XFILLER_3_751 VDD VSS sg13g2_decap_8
XFILLER_32_7 VDD VSS sg13g2_decap_8
XFILLER_78_596 VDD VSS sg13g2_decap_8
XFILLER_18_140 VDD VSS sg13g2_decap_8
XFILLER_33_110 VDD VSS sg13g2_decap_8
XFILLER_46_482 VDD VSS sg13g2_decap_4
XFILLER_74_780 VDD VSS sg13g2_decap_8
XFILLER_61_441 VDD VSS sg13g2_decap_8
XFILLER_73_290 VDD VSS sg13g2_fill_2
X_4811_ fanout293/X VSS VDD _4811_/D _4811_/Q _4817_/CLK sg13g2_dfrbpq_1
XFILLER_15_880 VDD VSS sg13g2_decap_8
XFILLER_15_891 VDD VSS sg13g2_fill_2
XFILLER_30_850 VDD VSS sg13g2_decap_8
XFILLER_33_198 VDD VSS sg13g2_decap_8
X_4742_ fanout272/X VSS VDD _4742_/D _4742_/Q _4745_/CLK sg13g2_dfrbpq_1
X_4407__519 VDD VSS _4407_/RESET_B sg13g2_tiehi
X_4673_ fanout253/X VSS VDD _4673_/D _4673_/Q _4673_/CLK sg13g2_dfrbpq_1
X_3624_ _3624_/A0 _4631_/Q _3653_/S _3624_/X VDD VSS sg13g2_mux2_1
XFILLER_116_922 VDD VSS sg13g2_decap_4
XFILLER_115_432 VDD VSS sg13g2_decap_4
X_3555_ _3608_/A _3555_/A _3556_/B VDD VSS sg13g2_nand2_1
XFILLER_115_454 VDD VSS sg13g2_fill_1
X_3486_ _3485_/Y VDD _3486_/Y VSS _2287_/Y _3490_/S sg13g2_o21ai_1
X_2506_ _4564_/Q _4565_/Q _3158_/A _3154_/B _2508_/D VDD VSS sg13g2_nor4_1
XFILLER_102_126 VDD VSS sg13g2_decap_8
XFILLER_103_649 VDD VSS sg13g2_decap_8
X_2437_ _2437_/Y _2437_/B _2433_/Y VDD VSS sg13g2_nand2b_1
XFILLER_69_563 VDD VSS sg13g2_decap_8
XFILLER_29_427 VDD VSS sg13g2_fill_1
XFILLER_56_202 VDD VSS sg13g2_decap_8
XFILLER_57_725 VDD VSS sg13g2_decap_8
X_2368_ _4681_/Q _4673_/Q _2379_/D VDD VSS sg13g2_nor2_1
XFILLER_110_170 VDD VSS sg13g2_decap_4
X_4107_ VSS VDD _4253_/A1 _4105_/X _4107_/Y _4106_/Y sg13g2_a21oi_1
X_2299_ VDD _2582_/A _2299_/A VSS sg13g2_inv_1
X_4038_ _4038_/A _4414_/Q _4038_/Y VDD VSS sg13g2_nor2_1
XFILLER_37_471 VDD VSS sg13g2_decap_8
XFILLER_37_482 VDD VSS sg13g2_fill_2
XFILLER_13_817 VDD VSS sg13g2_decap_8
XFILLER_52_441 VDD VSS sg13g2_fill_2
XFILLER_12_305 VDD VSS sg13g2_decap_8
XFILLER_24_187 VDD VSS sg13g2_decap_4
XFILLER_80_772 VDD VSS sg13g2_decap_8
XFILLER_21_850 VDD VSS sg13g2_decap_8
XFILLER_20_382 VDD VSS sg13g2_fill_1
XFILLER_0_732 VDD VSS sg13g2_decap_8
XFILLER_106_498 VDD VSS sg13g2_decap_8
XFILLER_79_338 VDD VSS sg13g2_fill_2
XFILLER_95_809 VDD VSS sg13g2_decap_8
XFILLER_102_660 VDD VSS sg13g2_fill_1
XFILLER_102_693 VDD VSS sg13g2_decap_8
XFILLER_47_246 VDD VSS sg13g2_fill_1
XFILLER_35_408 VDD VSS sg13g2_decap_4
XFILLER_47_279 VDD VSS sg13g2_decap_8
XFILLER_75_577 VDD VSS sg13g2_decap_8
XFILLER_75_599 VDD VSS sg13g2_decap_8
XFILLER_90_558 VDD VSS sg13g2_fill_2
XFILLER_15_165 VDD VSS sg13g2_decap_8
XFILLER_15_176 VDD VSS sg13g2_decap_8
XFILLER_30_168 VDD VSS sg13g2_decap_8
XFILLER_11_371 VDD VSS sg13g2_decap_4
XFILLER_116_207 VDD VSS sg13g2_decap_8
XFILLER_8_876 VDD VSS sg13g2_decap_8
XFILLER_7_89 VDD VSS sg13g2_decap_8
X_3340_ VSS VDD _3335_/Y _3337_/Y _3489_/D _3339_/Y sg13g2_a21oi_1
XFILLER_79_861 VDD VSS sg13g2_decap_8
X_3271_ _3271_/A _3270_/Y _3271_/Y VDD VSS sg13g2_nor2b_1
XFILLER_97_146 VDD VSS sg13g2_fill_1
XFILLER_97_135 VDD VSS sg13g2_decap_8
XFILLER_38_202 VDD VSS sg13g2_decap_8
XFILLER_39_714 VDD VSS sg13g2_decap_4
XFILLER_39_725 VDD VSS sg13g2_fill_2
Xhold1009 _4479_/Q VDD VSS _3540_/A1 sg13g2_dlygate4sd3_1
XFILLER_66_555 VDD VSS sg13g2_decap_4
XFILLER_78_382 VDD VSS sg13g2_decap_8
XFILLER_94_842 VDD VSS sg13g2_decap_8
XFILLER_19_460 VDD VSS sg13g2_decap_8
XFILLER_81_514 VDD VSS sg13g2_decap_8
XFILLER_93_374 VDD VSS sg13g2_decap_8
XFILLER_34_463 VDD VSS sg13g2_decap_8
XFILLER_62_772 VDD VSS sg13g2_decap_8
XFILLER_21_113 VDD VSS sg13g2_fill_1
XFILLER_22_647 VDD VSS sg13g2_decap_8
XFILLER_21_146 VDD VSS sg13g2_decap_8
X_2986_ _4029_/B _3088_/A0 _3003_/S _2986_/X VDD VSS sg13g2_mux2_1
XFILLER_108_708 VDD VSS sg13g2_decap_8
X_4725_ fanout327/X VSS VDD _4725_/D _4725_/Q _4870_/CLK sg13g2_dfrbpq_1
XFILLER_107_218 VDD VSS sg13g2_decap_8
X_4656_ fanout263/X VSS VDD _4656_/D _4656_/Q _4673_/CLK sg13g2_dfrbpq_1
Xhold821 _4274_/Q VDD VSS hold821/X sg13g2_dlygate4sd3_1
Xhold810 _4528_/Q VDD VSS hold810/X sg13g2_dlygate4sd3_1
X_4587_ fanout280/X VSS VDD _4587_/D _4587_/Q _4946_/CLK sg13g2_dfrbpq_1
X_3607_ _3608_/B _3607_/A _3607_/B VDD VSS sg13g2_xnor2_1
Xhold854 _4497_/Q VDD VSS hold854/X sg13g2_dlygate4sd3_1
Xhold843 _4276_/Q VDD VSS hold843/X sg13g2_dlygate4sd3_1
Xhold832 _2986_/X VDD VSS _4413_/D sg13g2_dlygate4sd3_1
X_3538_ _4700_/Q _3538_/A1 _3551_/S _3538_/X VDD VSS sg13g2_mux2_1
XFILLER_116_796 VDD VSS sg13g2_decap_8
Xhold898 _4346_/Q VDD VSS hold898/X sg13g2_dlygate4sd3_1
Xhold887 _4453_/Q VDD VSS hold887/X sg13g2_dlygate4sd3_1
Xhold876 _4421_/Q VDD VSS hold876/X sg13g2_dlygate4sd3_1
Xhold865 _4404_/Q VDD VSS hold865/X sg13g2_dlygate4sd3_1
XFILLER_103_457 VDD VSS sg13g2_fill_2
XFILLER_67_28 VDD VSS sg13g2_decap_8
X_3469_ _3483_/B _3469_/C _3469_/A _3469_/Y VDD VSS sg13g2_nand3_1
XFILLER_76_319 VDD VSS sg13g2_decap_8
Xhold1510 _3176_/X VDD VSS _3177_/B sg13g2_dlygate4sd3_1
XFILLER_88_179 VDD VSS sg13g2_decap_8
XFILLER_85_820 VDD VSS sg13g2_decap_8
XFILLER_111_490 VDD VSS sg13g2_decap_8
Xhold1521 _4949_/Q VDD VSS _2739_/B sg13g2_dlygate4sd3_1
Xhold1532 _4607_/Q VDD VSS _3253_/A sg13g2_dlygate4sd3_1
Xhold1543 _4758_/Q VDD VSS _3733_/B sg13g2_dlygate4sd3_1
XFILLER_17_419 VDD VSS sg13g2_decap_8
XFILLER_29_268 VDD VSS sg13g2_decap_8
Xhold1554 _4592_/Q VDD VSS _3217_/A sg13g2_dlygate4sd3_1
Xhold1565 _4876_/Q VDD VSS _2543_/B sg13g2_dlygate4sd3_1
Xhold1576 _3581_/Y VDD VSS _4720_/D sg13g2_dlygate4sd3_1
XFILLER_85_864 VDD VSS sg13g2_decap_8
XFILLER_57_599 VDD VSS sg13g2_decap_8
Xhold1587 _4762_/Q VDD VSS _3796_/B sg13g2_dlygate4sd3_1
Xhold1598 _4610_/Q VDD VSS _2611_/B sg13g2_dlygate4sd3_1
XFILLER_13_669 VDD VSS sg13g2_decap_8
XFILLER_40_455 VDD VSS sg13g2_decap_8
XFILLER_12_179 VDD VSS sg13g2_decap_8
XFILLER_21_691 VDD VSS sg13g2_decap_8
XFILLER_5_802 VDD VSS sg13g2_decap_8
XFILLER_5_879 VDD VSS sg13g2_decap_8
XFILLER_106_262 VDD VSS sg13g2_decap_8
XFILLER_106_273 VDD VSS sg13g2_fill_1
XFILLER_107_796 VDD VSS sg13g2_decap_8
XFILLER_79_157 VDD VSS sg13g2_fill_1
XFILLER_57_61 VDD VSS sg13g2_decap_8
XFILLER_76_831 VDD VSS sg13g2_decap_8
XFILLER_63_503 VDD VSS sg13g2_decap_8
XFILLER_76_886 VDD VSS sg13g2_fill_2
XFILLER_29_791 VDD VSS sg13g2_decap_8
XFILLER_36_739 VDD VSS sg13g2_decap_8
XFILLER_90_300 VDD VSS sg13g2_decap_8
XFILLER_63_558 VDD VSS sg13g2_decap_8
XFILLER_90_344 VDD VSS sg13g2_fill_1
XFILLER_44_783 VDD VSS sg13g2_decap_8
XFILLER_16_496 VDD VSS sg13g2_decap_8
X_2840_ _2840_/A0 _3026_/A1 _2847_/S _2840_/X VDD VSS sg13g2_mux2_1
X_2771_ _2771_/B _2771_/C _2771_/A _2774_/B VDD VSS sg13g2_nand3_1
XFILLER_8_640 VDD VSS sg13g2_decap_4
X_4510_ _2849_/C VSS VDD _4510_/D _4510_/Q _4931_/CLK sg13g2_dfrbpq_1
X_4441_ _4441_/RESET_B VSS VDD _4441_/D _4441_/Q _4960_/CLK sg13g2_dfrbpq_1
X_4372_ _4372_/RESET_B VSS VDD _4372_/D _4372_/Q _4397_/CLK sg13g2_dfrbpq_1
XFILLER_101_906 VDD VSS sg13g2_decap_8
XFILLER_112_221 VDD VSS sg13g2_fill_1
X_3323_ _3329_/A _4785_/Q _3399_/B VDD VSS sg13g2_nor2_1
XFILLER_98_433 VDD VSS sg13g2_decap_8
XFILLER_21_0 VDD VSS sg13g2_decap_8
X_3254_ VSS VDD _3278_/A _3253_/Y _4607_/D _3289_/A sg13g2_a21oi_1
XFILLER_67_842 VDD VSS sg13g2_fill_1
XFILLER_67_886 VDD VSS sg13g2_fill_1
X_3185_ _3185_/A hold1649/X _4577_/D VDD VSS sg13g2_nor2b_1
XFILLER_54_525 VDD VSS sg13g2_decap_8
XFILLER_93_171 VDD VSS sg13g2_decap_8
XFILLER_82_878 VDD VSS sg13g2_decap_8
XFILLER_22_400 VDD VSS sg13g2_decap_8
XFILLER_41_208 VDD VSS sg13g2_decap_8
XFILLER_41_219 VDD VSS sg13g2_fill_1
XFILLER_34_271 VDD VSS sg13g2_decap_8
XFILLER_22_499 VDD VSS sg13g2_decap_8
X_2969_ _2969_/A0 _3098_/A0 _2980_/S _4398_/D VDD VSS sg13g2_mux2_1
XFILLER_108_505 VDD VSS sg13g2_decap_8
X_4708_ fanout311/X VSS VDD _4708_/D _4708_/Q _4869_/CLK sg13g2_dfrbpq_1
X_4639_ fanout272/X VSS VDD _4639_/D _4639_/Q _4749_/CLK sg13g2_dfrbpq_1
XFILLER_2_827 VDD VSS sg13g2_decap_8
Xhold662 _2796_/Y VDD VSS _2797_/C sg13g2_dlygate4sd3_1
Xhold651 _4978_/Q VDD VSS _4246_/B sg13g2_dlygate4sd3_1
Xhold640 _4975_/Q VDD VSS _4219_/B sg13g2_dlygate4sd3_1
XFILLER_103_210 VDD VSS sg13g2_decap_8
XFILLER_103_232 VDD VSS sg13g2_decap_8
XFILLER_1_359 VDD VSS sg13g2_decap_8
Xhold695 _4977_/Q VDD VSS _4237_/B sg13g2_dlygate4sd3_1
Xhold684 _4089_/Y VDD VSS _4962_/D sg13g2_dlygate4sd3_1
Xhold673 _3139_/Y VDD VSS _4557_/D sg13g2_dlygate4sd3_1
XFILLER_49_308 VDD VSS sg13g2_fill_1
XFILLER_76_105 VDD VSS sg13g2_fill_1
XFILLER_45_503 VDD VSS sg13g2_decap_8
Xhold1340 _2435_/Y VDD VSS _2436_/B sg13g2_dlygate4sd3_1
Xhold1351 _3961_/Y VDD VSS _4824_/D sg13g2_dlygate4sd3_1
XFILLER_27_42 VDD VSS sg13g2_decap_8
XFILLER_45_514 VDD VSS sg13g2_fill_2
XFILLER_72_322 VDD VSS sg13g2_decap_4
Xhold1362 _4651_/Q VDD VSS _2262_/A sg13g2_dlygate4sd3_1
Xhold1373 _3146_/Y VDD VSS _4560_/D sg13g2_dlygate4sd3_1
Xhold1384 _4682_/Q VDD VSS _3487_/A sg13g2_dlygate4sd3_1
Xhold1395 _3850_/Y VDD VSS _3853_/B1 sg13g2_dlygate4sd3_1
XFILLER_73_856 VDD VSS sg13g2_decap_8
XFILLER_60_506 VDD VSS sg13g2_fill_2
XFILLER_41_731 VDD VSS sg13g2_decap_8
XFILLER_41_742 VDD VSS sg13g2_fill_2
XFILLER_13_466 VDD VSS sg13g2_decap_8
XFILLER_9_415 VDD VSS sg13g2_decap_8
XFILLER_9_459 VDD VSS sg13g2_decap_8
XFILLER_5_643 VDD VSS sg13g2_decap_8
XFILLER_107_571 VDD VSS sg13g2_decap_8
XFILLER_4_197 VDD VSS sg13g2_decap_8
XFILLER_4_35 VDD VSS sg13g2_decap_8
XFILLER_67_105 VDD VSS sg13g2_decap_8
XFILLER_68_60 VDD VSS sg13g2_decap_8
XFILLER_95_414 VDD VSS sg13g2_decap_8
XFILLER_110_747 VDD VSS sg13g2_decap_8
XFILLER_110_758 VDD VSS sg13g2_fill_1
XFILLER_49_864 VDD VSS sg13g2_decap_8
XFILLER_36_525 VDD VSS sg13g2_decap_8
XFILLER_48_385 VDD VSS sg13g2_decap_8
XFILLER_63_322 VDD VSS sg13g2_decap_8
XFILLER_64_845 VDD VSS sg13g2_decap_8
XFILLER_76_672 VDD VSS sg13g2_decap_8
XFILLER_91_631 VDD VSS sg13g2_decap_8
XFILLER_36_558 VDD VSS sg13g2_decap_8
XFILLER_23_208 VDD VSS sg13g2_decap_8
XFILLER_16_271 VDD VSS sg13g2_decap_8
XFILLER_51_539 VDD VSS sg13g2_decap_8
X_3941_ VSS VDD _3948_/C _3944_/C _3941_/Y _3944_/A sg13g2_a21oi_1
X_3872_ VSS VDD _3871_/A _3879_/D _4800_/D _3871_/Y sg13g2_a21oi_1
X_2823_ _4796_/Q _4795_/Q _2983_/A _2823_/Y VDD VSS sg13g2_nor3_1
X_2754_ _2753_/Y VDD _2755_/A VSS _2754_/A1 _2752_/C sg13g2_o21ai_1
XFILLER_69_0 VDD VSS sg13g2_decap_4
X_2685_ _4726_/Q _2685_/C _4719_/Q _2692_/C VDD VSS _2685_/D sg13g2_nand4_1
X_4424_ _4424_/RESET_B VSS VDD _4424_/D _4424_/Q _4968_/CLK sg13g2_dfrbpq_1
X_4355_ _4355_/RESET_B VSS VDD _4355_/D _4355_/Q _4966_/CLK sg13g2_dfrbpq_1
X_3306_ _3394_/A _3307_/B _3306_/X VDD VSS sg13g2_and2_1
XFILLER_98_252 VDD VSS sg13g2_decap_8
XFILLER_101_736 VDD VSS sg13g2_decap_8
X_4286_ _4286_/RESET_B VSS VDD _4286_/D _4286_/Q _4527_/CLK sg13g2_dfrbpq_1
XFILLER_98_296 VDD VSS sg13g2_decap_8
XFILLER_100_246 VDD VSS sg13g2_decap_8
XFILLER_104_14 VDD VSS sg13g2_decap_4
XFILLER_39_341 VDD VSS sg13g2_decap_8
X_3237_ VSS VDD _2602_/A _3232_/B _3237_/Y _3232_/A sg13g2_a21oi_1
XFILLER_55_823 VDD VSS sg13g2_decap_8
X_3168_ _3184_/B VDD _3168_/Y VSS _3179_/B1 _3168_/A2 sg13g2_o21ai_1
XFILLER_27_558 VDD VSS sg13g2_decap_8
XFILLER_27_569 VDD VSS sg13g2_fill_1
XFILLER_54_355 VDD VSS sg13g2_decap_8
XFILLER_94_491 VDD VSS sg13g2_decap_8
XFILLER_55_889 VDD VSS sg13g2_decap_8
X_3099_ _3099_/A0 _3124_/A1 _3108_/S _4523_/D VDD VSS sg13g2_mux2_1
XFILLER_81_196 VDD VSS sg13g2_fill_1
XFILLER_11_915 VDD VSS sg13g2_decap_8
XFILLER_22_241 VDD VSS sg13g2_decap_8
XFILLER_80_28 VDD VSS sg13g2_decap_8
Xfanout23 _3828_/A2 _3837_/A2 VDD VSS sg13g2_buf_1
Xfanout34 _2391_/Y _2807_/A VDD VSS sg13g2_buf_1
Xfanout45 _3483_/C _3469_/C VDD VSS sg13g2_buf_1
Xfanout56 _3344_/Y _3444_/A2 VDD VSS sg13g2_buf_1
X_4426__500 VDD VSS _4426_/RESET_B sg13g2_tiehi
Xfanout67 _2471_/Y fanout67/X VDD VSS sg13g2_buf_1
Xfanout78 _3028_/S _3034_/S VDD VSS sg13g2_buf_1
Xfanout89 fanout93/X _2953_/S VDD VSS sg13g2_buf_1
XFILLER_108_313 VDD VSS sg13g2_decap_8
XFILLER_13_88 VDD VSS sg13g2_decap_8
XFILLER_6_418 VDD VSS sg13g2_decap_8
XFILLER_108_368 VDD VSS sg13g2_decap_8
XFILLER_89_230 VDD VSS sg13g2_decap_8
XFILLER_1_167 VDD VSS sg13g2_fill_2
XFILLER_1_178 VDD VSS sg13g2_decap_8
XFILLER_1_189 VDD VSS sg13g2_fill_2
XFILLER_49_116 VDD VSS sg13g2_decap_8
XFILLER_77_447 VDD VSS sg13g2_decap_8
XFILLER_38_63 VDD VSS sg13g2_fill_2
XFILLER_46_801 VDD VSS sg13g2_decap_8
XFILLER_58_650 VDD VSS sg13g2_decap_8
XFILLER_18_514 VDD VSS sg13g2_decap_8
XFILLER_38_96 VDD VSS sg13g2_decap_8
XFILLER_45_311 VDD VSS sg13g2_decap_8
XFILLER_57_160 VDD VSS sg13g2_fill_1
XFILLER_57_171 VDD VSS sg13g2_decap_8
XFILLER_58_694 VDD VSS sg13g2_decap_8
XFILLER_64_108 VDD VSS sg13g2_decap_8
Xhold1170 _4438_/Q VDD VSS _4030_/A2 sg13g2_dlygate4sd3_1
XFILLER_100_791 VDD VSS sg13g2_decap_8
XFILLER_61_804 VDD VSS sg13g2_fill_1
XFILLER_72_130 VDD VSS sg13g2_decap_8
Xhold1181 _4351_/Q VDD VSS _2919_/A0 sg13g2_dlygate4sd3_1
Xhold1192 _2971_/X VDD VSS _4400_/D sg13g2_dlygate4sd3_1
XFILLER_33_528 VDD VSS sg13g2_fill_2
XFILLER_45_399 VDD VSS sg13g2_fill_1
XFILLER_60_314 VDD VSS sg13g2_decap_8
XFILLER_72_196 VDD VSS sg13g2_fill_1
XFILLER_41_561 VDD VSS sg13g2_decap_8
XFILLER_60_358 VDD VSS sg13g2_fill_1
XFILLER_9_256 VDD VSS sg13g2_decap_8
Xclkload15 clkload15/Y _4946_/CLK VDD VSS sg13g2_inv_2
Xclkload26 _4877_/CLK clkload26/Y VDD VSS sg13g2_inv_4
XFILLER_62_7 VDD VSS sg13g2_decap_8
Xclkload37 VDD clkload37/Y _4870_/CLK VSS sg13g2_inv_1
XFILLER_114_316 VDD VSS sg13g2_decap_8
X_2470_ _2470_/A _2470_/B _4931_/Q _2470_/D _2470_/Y VDD VSS sg13g2_nor4_1
X_4140_ _4139_/Y VDD _4140_/Y VSS _4136_/Y _4138_/Y sg13g2_o21ai_1
XFILLER_68_425 VDD VSS sg13g2_decap_8
XFILLER_95_233 VDD VSS sg13g2_decap_8
XFILLER_110_566 VDD VSS sg13g2_fill_2
XFILLER_37_801 VDD VSS sg13g2_decap_8
X_4071_ VSS VDD _4253_/A1 _4070_/X _4071_/Y _4218_/A1 sg13g2_a21oi_1
XFILLER_49_694 VDD VSS sg13g2_decap_4
X_3022_ _3022_/A0 hold896/X _3033_/S _4448_/D VDD VSS sg13g2_mux2_1
XFILLER_63_130 VDD VSS sg13g2_fill_1
XFILLER_24_506 VDD VSS sg13g2_decap_8
XFILLER_37_878 VDD VSS sg13g2_fill_1
XFILLER_64_686 VDD VSS sg13g2_decap_8
XFILLER_91_450 VDD VSS sg13g2_decap_8
XFILLER_51_336 VDD VSS sg13g2_fill_1
XFILLER_52_859 VDD VSS sg13g2_fill_2
X_4973_ fanout287/X VSS VDD _4973_/D _4973_/Q _4973_/CLK sg13g2_dfrbpq_1
XFILLER_91_483 VDD VSS sg13g2_decap_8
X_3924_ _3930_/A _3929_/A _3924_/C _3925_/B VDD VSS sg13g2_nor3_1
Xclkload9 clkload9/Y clkload9/A VDD VSS sg13g2_inv_2
X_3855_ _3855_/Y _3852_/A _3854_/Y _3791_/S _3390_/A VDD VSS sg13g2_a22oi_1
XFILLER_20_789 VDD VSS sg13g2_decap_8
X_3786_ _3786_/A _3786_/B _3786_/C _3786_/Y VDD VSS sg13g2_nor3_1
X_2806_ _2806_/A _2806_/B _2806_/Y VDD VSS sg13g2_nor2_1
X_2737_ VDD _4948_/D _2737_/A VSS sg13g2_inv_1
XFILLER_105_305 VDD VSS sg13g2_decap_8
XFILLER_106_839 VDD VSS sg13g2_decap_8
X_2668_ _2670_/B _4698_/Q _2330_/A VDD VSS sg13g2_nand2b_1
X_4407_ _4407_/RESET_B VSS VDD _4407_/D _4407_/Q _4959_/CLK sg13g2_dfrbpq_1
Xfanout202 _4825_/Q _4187_/A VDD VSS sg13g2_buf_1
Xfanout213 hold1664/X _3563_/B VDD VSS sg13g2_buf_1
X_2599_ VSS VDD _2601_/D _2599_/B _4597_/Q sg13g2_or2_1
XFILLER_99_572 VDD VSS sg13g2_decap_8
XFILLER_87_712 VDD VSS sg13g2_decap_8
XFILLER_101_500 VDD VSS sg13g2_decap_8
XFILLER_101_522 VDD VSS sg13g2_fill_2
XFILLER_59_414 VDD VSS sg13g2_fill_2
XFILLER_59_436 VDD VSS sg13g2_decap_8
Xfanout224 hold823/X _3107_/A0 VDD VSS sg13g2_buf_1
Xfanout235 hold1390/X _3096_/A0 VDD VSS sg13g2_buf_1
Xfanout246 fanout248/X fanout246/X VDD VSS sg13g2_buf_1
X_4338_ _4338_/RESET_B VSS VDD _4338_/D _4338_/Q _4926_/CLK sg13g2_dfrbpq_1
XFILLER_101_555 VDD VSS sg13g2_decap_8
Xfanout257 fanout260/X fanout257/X VDD VSS sg13g2_buf_1
Xfanout268 fanout269/X fanout268/X VDD VSS sg13g2_buf_1
Xfanout279 fanout283/X fanout279/X VDD VSS sg13g2_buf_1
X_4269_ _4269_/RESET_B VSS VDD _4269_/D _4269_/Q _4927_/CLK sg13g2_dfrbpq_1
XFILLER_101_588 VDD VSS sg13g2_decap_8
XFILLER_28_834 VDD VSS sg13g2_fill_2
XFILLER_46_108 VDD VSS sg13g2_decap_8
XFILLER_28_845 VDD VSS sg13g2_decap_8
XFILLER_54_130 VDD VSS sg13g2_fill_1
XFILLER_27_366 VDD VSS sg13g2_decap_8
XFILLER_27_377 VDD VSS sg13g2_fill_1
XFILLER_28_889 VDD VSS sg13g2_fill_1
XFILLER_54_163 VDD VSS sg13g2_decap_8
XFILLER_27_388 VDD VSS sg13g2_decap_4
XFILLER_43_837 VDD VSS sg13g2_decap_8
XFILLER_55_697 VDD VSS sg13g2_decap_4
XFILLER_91_49 VDD VSS sg13g2_decap_8
XFILLER_30_509 VDD VSS sg13g2_decap_8
XFILLER_70_656 VDD VSS sg13g2_decap_8
XFILLER_11_745 VDD VSS sg13g2_decap_8
XFILLER_50_380 VDD VSS sg13g2_fill_1
XFILLER_10_266 VDD VSS sg13g2_decap_8
XFILLER_6_226 VDD VSS sg13g2_decap_8
XFILLER_108_176 VDD VSS sg13g2_decap_8
XFILLER_40_64 VDD VSS sg13g2_decap_8
XFILLER_2_465 VDD VSS sg13g2_decap_8
XFILLER_77_222 VDD VSS sg13g2_decap_8
XFILLER_78_734 VDD VSS sg13g2_decap_8
X_4318__408 VDD VSS _4318_/RESET_B sg13g2_tiehi
XFILLER_104_393 VDD VSS sg13g2_decap_8
XFILLER_1_14 VDD VSS sg13g2_decap_8
XFILLER_49_95 VDD VSS sg13g2_decap_8
XFILLER_93_748 VDD VSS sg13g2_decap_8
XFILLER_18_377 VDD VSS sg13g2_fill_1
XFILLER_34_815 VDD VSS sg13g2_decap_8
XFILLER_45_130 VDD VSS sg13g2_decap_8
XFILLER_33_325 VDD VSS sg13g2_decap_8
XFILLER_45_196 VDD VSS sg13g2_decap_8
XFILLER_60_144 VDD VSS sg13g2_decap_8
XFILLER_61_656 VDD VSS sg13g2_fill_1
XFILLER_61_667 VDD VSS sg13g2_fill_2
XFILLER_14_572 VDD VSS sg13g2_decap_8
XFILLER_14_583 VDD VSS sg13g2_fill_2
XFILLER_61_689 VDD VSS sg13g2_decap_8
XFILLER_14_594 VDD VSS sg13g2_decap_8
XFILLER_41_391 VDD VSS sg13g2_decap_8
X_3640_ _3640_/B _3698_/C _3718_/A _3643_/B VDD VSS sg13g2_nand3_1
X_3571_ VDD _3582_/B _3571_/A VSS sg13g2_inv_1
X_2522_ _2813_/A _4650_/D _4927_/D VDD VSS sg13g2_and2_1
XFILLER_5_281 VDD VSS sg13g2_decap_8
X_2453_ _4929_/D _4928_/D _2453_/C _3868_/B VDD VSS sg13g2_nor3_1
X_4416__510 VDD VSS _4416_/RESET_B sg13g2_tiehi
X_2384_ _2361_/Y VDD _2386_/C VSS _4660_/Q _4652_/Q sg13g2_o21ai_1
X_4123_ _4231_/A _4272_/Q _4297_/Q _4322_/Q _4347_/Q _2347_/A _4123_/X VDD VSS sg13g2_mux4_1
XFILLER_110_363 VDD VSS sg13g2_decap_8
XFILLER_68_266 VDD VSS sg13g2_decap_8
XFILLER_83_203 VDD VSS sg13g2_decap_8
Xinput2 record_req input2/X VDD VSS sg13g2_buf_1
X_4054_ _4218_/A1 VDD _4054_/Y VSS _4052_/Y _4053_/Y sg13g2_o21ai_1
XFILLER_96_597 VDD VSS sg13g2_decap_8
XFILLER_83_236 VDD VSS sg13g2_fill_2
X_3005_ _3005_/A0 _3107_/A0 _3007_/S _4432_/D VDD VSS sg13g2_mux2_1
XFILLER_37_653 VDD VSS sg13g2_decap_8
XFILLER_92_770 VDD VSS sg13g2_decap_8
XFILLER_80_921 VDD VSS sg13g2_decap_4
XFILLER_92_781 VDD VSS sg13g2_fill_2
XFILLER_24_347 VDD VSS sg13g2_fill_1
XFILLER_51_133 VDD VSS sg13g2_decap_8
XFILLER_33_870 VDD VSS sg13g2_fill_2
X_4956_ fanout298/X VSS VDD _4956_/D _4956_/Q _4959_/CLK sg13g2_dfrbpq_1
XFILLER_20_542 VDD VSS sg13g2_fill_1
X_4887_ fanout309/X VSS VDD _4887_/D _4887_/Q _4894_/CLK sg13g2_dfrbpq_1
X_4423__503 VDD VSS _4423_/RESET_B sg13g2_tiehi
X_3907_ _3907_/A _3907_/B _3907_/C _3907_/Y VDD VSS sg13g2_nor3_1
X_3838_ VSS VDD _3835_/A _3835_/B _3838_/Y _2294_/Y sg13g2_a21oi_1
XFILLER_3_207 VDD VSS sg13g2_fill_2
X_3769_ _3767_/Y VDD _4768_/D VSS _3786_/B _3768_/Y sg13g2_o21ai_1
XFILLER_106_636 VDD VSS sg13g2_decap_8
XFILLER_0_914 VDD VSS sg13g2_decap_8
XFILLER_10_56 VDD VSS sg13g2_decap_8
XFILLER_0_925 VDD VSS sg13g2_fill_1
XFILLER_114_680 VDD VSS sg13g2_decap_8
XFILLER_101_330 VDD VSS sg13g2_decap_8
XFILLER_102_842 VDD VSS sg13g2_decap_8
XFILLER_19_21 VDD VSS sg13g2_decap_8
XFILLER_75_726 VDD VSS sg13g2_decap_8
XFILLER_28_620 VDD VSS sg13g2_decap_8
XFILLER_47_439 VDD VSS sg13g2_decap_8
XFILLER_62_409 VDD VSS sg13g2_decap_8
XFILLER_71_910 VDD VSS sg13g2_decap_8
XFILLER_74_269 VDD VSS sg13g2_fill_2
XFILLER_15_303 VDD VSS sg13g2_fill_2
XFILLER_28_697 VDD VSS sg13g2_decap_8
XFILLER_42_100 VDD VSS sg13g2_decap_8
XFILLER_43_623 VDD VSS sg13g2_decap_8
XFILLER_55_483 VDD VSS sg13g2_decap_8
XFILLER_83_792 VDD VSS sg13g2_decap_8
XFILLER_42_155 VDD VSS sg13g2_decap_8
XFILLER_70_464 VDD VSS sg13g2_decap_8
XFILLER_11_564 VDD VSS sg13g2_decap_4
XFILLER_7_502 VDD VSS sg13g2_decap_8
XFILLER_11_586 VDD VSS sg13g2_decap_8
XFILLER_7_535 VDD VSS sg13g2_decap_8
XFILLER_109_496 VDD VSS sg13g2_decap_4
XFILLER_3_730 VDD VSS sg13g2_decap_8
XFILLER_111_127 VDD VSS sg13g2_fill_2
XFILLER_97_317 VDD VSS sg13g2_fill_2
XFILLER_111_149 VDD VSS sg13g2_decap_8
XFILLER_25_7 VDD VSS sg13g2_decap_8
XFILLER_2_295 VDD VSS sg13g2_decap_8
XFILLER_78_575 VDD VSS sg13g2_decap_8
XFILLER_65_236 VDD VSS sg13g2_decap_8
XFILLER_53_409 VDD VSS sg13g2_decap_8
XFILLER_19_697 VDD VSS sg13g2_decap_8
XFILLER_61_420 VDD VSS sg13g2_decap_8
XFILLER_80_228 VDD VSS sg13g2_fill_1
XFILLER_22_807 VDD VSS sg13g2_fill_2
XFILLER_34_656 VDD VSS sg13g2_fill_2
X_4810_ fanout293/X VSS VDD _4810_/D _4810_/Q _4817_/CLK sg13g2_dfrbpq_1
XFILLER_92_70 VDD VSS sg13g2_decap_8
XFILLER_33_177 VDD VSS sg13g2_decap_8
X_4741_ fanout273/X VSS VDD _4741_/D _4741_/Q _4942_/CLK sg13g2_dfrbpq_1
X_4672_ fanout251/X VSS VDD _4672_/D _4672_/Q clkload4/A sg13g2_dfrbpq_1
X_3623_ _3623_/A0 _3623_/A1 _3653_/S _4735_/D VDD VSS sg13g2_mux2_1
XFILLER_116_901 VDD VSS sg13g2_decap_8
XFILLER_115_411 VDD VSS sg13g2_decap_4
XFILLER_115_422 VDD VSS sg13g2_fill_1
XFILLER_51_0 VDD VSS sg13g2_decap_8
X_3554_ VSS VDD _3523_/A _3596_/B _3558_/A _2256_/Y sg13g2_a21oi_1
X_3485_ _3489_/B _3490_/S _3485_/A _3485_/Y VDD VSS sg13g2_nand3_1
X_2505_ _4565_/Q _3156_/B _3158_/B VDD VSS sg13g2_nor2_1
XFILLER_102_105 VDD VSS sg13g2_decap_8
XFILLER_115_488 VDD VSS sg13g2_decap_8
X_2436_ _2436_/Y _2436_/B _2806_/B VDD VSS sg13g2_nand2b_1
XFILLER_69_542 VDD VSS sg13g2_decap_8
XFILLER_111_650 VDD VSS sg13g2_fill_2
XFILLER_29_406 VDD VSS sg13g2_decap_8
XFILLER_57_704 VDD VSS sg13g2_decap_8
X_2367_ _2379_/C _4661_/Q _4653_/Q VDD VSS sg13g2_xnor2_1
XFILLER_110_193 VDD VSS sg13g2_fill_2
XFILLER_56_225 VDD VSS sg13g2_decap_8
X_4106_ _2348_/A VDD _4106_/Y VSS _4103_/Y _4104_/Y sg13g2_o21ai_1
X_2298_ VDD _2552_/A _2549_/A VSS sg13g2_inv_1
XFILLER_112_14 VDD VSS sg13g2_decap_8
XFILLER_2_90 VDD VSS sg13g2_decap_8
XFILLER_44_409 VDD VSS sg13g2_fill_2
X_4037_ _4364_/Q _4389_/Q _4038_/A _4037_/X VDD VSS sg13g2_mux2_1
XFILLER_37_494 VDD VSS sg13g2_decap_4
XFILLER_52_420 VDD VSS sg13g2_decap_8
XFILLER_64_280 VDD VSS sg13g2_decap_8
XFILLER_71_228 VDD VSS sg13g2_decap_8
XFILLER_80_751 VDD VSS sg13g2_decap_8
XFILLER_24_166 VDD VSS sg13g2_decap_8
XFILLER_52_475 VDD VSS sg13g2_decap_8
XFILLER_80_795 VDD VSS sg13g2_decap_8
XFILLER_12_339 VDD VSS sg13g2_decap_4
X_4939_ fanout334/X VSS VDD _4939_/D _4939_/Q _4941_/CLK sg13g2_dfrbpq_1
X_4308__418 VDD VSS _4308_/RESET_B sg13g2_tiehi
XFILLER_21_11 VDD VSS sg13g2_fill_2
XFILLER_21_55 VDD VSS sg13g2_fill_1
XFILLER_21_99 VDD VSS sg13g2_decap_8
XFILLER_79_306 VDD VSS sg13g2_fill_1
XFILLER_0_711 VDD VSS sg13g2_decap_8
XFILLER_106_477 VDD VSS sg13g2_decap_8
XFILLER_0_788 VDD VSS sg13g2_decap_8
XFILLER_48_715 VDD VSS sg13g2_decap_8
XFILLER_88_884 VDD VSS sg13g2_fill_2
XFILLER_87_383 VDD VSS sg13g2_decap_8
XFILLER_101_193 VDD VSS sg13g2_decap_8
XFILLER_47_258 VDD VSS sg13g2_decap_8
XFILLER_63_729 VDD VSS sg13g2_decap_8
XFILLER_75_556 VDD VSS sg13g2_decap_8
XFILLER_16_601 VDD VSS sg13g2_decap_4
XFILLER_46_74 VDD VSS sg13g2_decap_8
XFILLER_62_228 VDD VSS sg13g2_decap_8
XFILLER_62_239 VDD VSS sg13g2_fill_2
XFILLER_15_144 VDD VSS sg13g2_decap_8
XFILLER_43_431 VDD VSS sg13g2_decap_8
XFILLER_102_91 VDD VSS sg13g2_decap_8
XFILLER_30_125 VDD VSS sg13g2_decap_4
XFILLER_11_350 VDD VSS sg13g2_decap_8
XFILLER_30_147 VDD VSS sg13g2_decap_8
X_4406__520 VDD VSS _4406_/RESET_B sg13g2_tiehi
XFILLER_12_895 VDD VSS sg13g2_decap_8
XFILLER_8_855 VDD VSS sg13g2_decap_8
XFILLER_7_68 VDD VSS sg13g2_decap_8
XFILLER_109_282 VDD VSS sg13g2_fill_1
X_3270_ _4614_/Q VDD _3270_/Y VSS _2613_/A _3268_/B sg13g2_o21ai_1
XFILLER_98_648 VDD VSS sg13g2_decap_8
XFILLER_79_840 VDD VSS sg13g2_decap_8
XFILLER_23_4 VDD VSS sg13g2_fill_2
XFILLER_66_501 VDD VSS sg13g2_decap_8
XFILLER_78_361 VDD VSS sg13g2_decap_8
XFILLER_94_821 VDD VSS sg13g2_decap_8
XFILLER_87_81 VDD VSS sg13g2_decap_8
XFILLER_66_534 VDD VSS sg13g2_decap_8
X_4413__513 VDD VSS _4413_/RESET_B sg13g2_tiehi
XFILLER_26_409 VDD VSS sg13g2_decap_4
XFILLER_35_910 VDD VSS sg13g2_decap_8
XFILLER_47_792 VDD VSS sg13g2_decap_8
XFILLER_46_291 VDD VSS sg13g2_fill_1
XFILLER_62_751 VDD VSS sg13g2_decap_8
XFILLER_22_626 VDD VSS sg13g2_decap_8
XFILLER_50_924 VDD VSS sg13g2_fill_2
XFILLER_61_294 VDD VSS sg13g2_decap_8
XFILLER_99_0 VDD VSS sg13g2_decap_8
X_4724_ fanout327/X VSS VDD _4724_/D _4724_/Q _4870_/CLK sg13g2_dfrbpq_1
X_2985_ hold824/X _3087_/A0 _3008_/S _2985_/X VDD VSS sg13g2_mux2_1
XFILLER_30_681 VDD VSS sg13g2_decap_8
X_4655_ fanout253/X VSS VDD _4655_/D _4655_/Q _4673_/CLK sg13g2_dfrbpq_1
X_4420__506 VDD VSS _4420_/RESET_B sg13g2_tiehi
Xhold811 _4530_/Q VDD VSS hold811/X sg13g2_dlygate4sd3_1
Xhold800 _3874_/Y VDD VSS hold800/X sg13g2_dlygate4sd3_1
X_4586_ fanout280/X VSS VDD _4586_/D _4586_/Q _4946_/CLK sg13g2_dfrbpq_1
X_3606_ _4727_/Q _3607_/B _3612_/B VDD VSS sg13g2_and2_1
XFILLER_116_775 VDD VSS sg13g2_decap_8
Xhold855 _3046_/X VDD VSS _4472_/D sg13g2_dlygate4sd3_1
Xhold844 _2839_/X VDD VSS _4276_/D sg13g2_dlygate4sd3_1
Xhold833 _4368_/Q VDD VSS hold833/X sg13g2_dlygate4sd3_1
Xhold822 _2837_/X VDD VSS _4274_/D sg13g2_dlygate4sd3_1
X_3537_ _4699_/Q _3537_/A1 _3552_/S _3537_/X VDD VSS sg13g2_mux2_1
XFILLER_107_25 VDD VSS sg13g2_fill_2
XFILLER_115_285 VDD VSS sg13g2_decap_8
Xhold888 _3027_/X VDD VSS _4453_/D sg13g2_dlygate4sd3_1
Xhold877 _2994_/X VDD VSS _4421_/D sg13g2_dlygate4sd3_1
Xhold866 _4418_/Q VDD VSS hold866/X sg13g2_dlygate4sd3_1
XFILLER_103_436 VDD VSS sg13g2_decap_8
XFILLER_115_296 VDD VSS sg13g2_decap_8
Xhold899 _2914_/X VDD VSS _4346_/D sg13g2_dlygate4sd3_1
X_3468_ _3467_/Y VDD _4671_/D VSS _2286_/Y _3481_/C sg13g2_o21ai_1
XFILLER_88_125 VDD VSS sg13g2_fill_1
XFILLER_103_469 VDD VSS sg13g2_decap_8
Xhold1500 _3787_/X VDD VSS _4773_/D sg13g2_dlygate4sd3_1
X_3399_ _3399_/B _3399_/C _3399_/A _3400_/B VDD VSS sg13g2_nand3_1
X_2419_ _2419_/A _2425_/A _3407_/A _2419_/D _2422_/C VDD VSS sg13g2_nor4_1
XFILLER_97_681 VDD VSS sg13g2_decap_8
XFILLER_69_383 VDD VSS sg13g2_decap_8
XFILLER_84_320 VDD VSS sg13g2_decap_8
Xhold1511 _4766_/Q VDD VSS _3832_/A sg13g2_dlygate4sd3_1
Xhold1522 _2738_/Y VDD VSS hold1522/X sg13g2_dlygate4sd3_1
Xhold1533 _4674_/Q VDD VSS _3471_/A sg13g2_dlygate4sd3_1
Xhold1544 _3731_/Y VDD VSS _3734_/B1 sg13g2_dlygate4sd3_1
XFILLER_29_247 VDD VSS sg13g2_decap_8
XFILLER_57_578 VDD VSS sg13g2_decap_8
XFILLER_84_342 VDD VSS sg13g2_decap_8
Xhold1555 _3217_/X VDD VSS _3218_/B sg13g2_dlygate4sd3_1
Xhold1566 _2544_/X VDD VSS _2545_/B sg13g2_dlygate4sd3_1
Xhold1577 _4893_/Q VDD VSS _2299_/A sg13g2_dlygate4sd3_1
XFILLER_72_537 VDD VSS sg13g2_decap_8
Xhold1588 _3747_/Y VDD VSS _4762_/D sg13g2_dlygate4sd3_1
Xhold1599 _4950_/Q VDD VSS _2336_/A sg13g2_dlygate4sd3_1
XFILLER_16_44 VDD VSS sg13g2_fill_2
XFILLER_25_475 VDD VSS sg13g2_fill_2
XFILLER_40_401 VDD VSS sg13g2_fill_2
XFILLER_41_924 VDD VSS sg13g2_fill_2
XFILLER_13_648 VDD VSS sg13g2_decap_8
XFILLER_40_434 VDD VSS sg13g2_decap_8
XFILLER_32_21 VDD VSS sg13g2_decap_8
XFILLER_21_670 VDD VSS sg13g2_decap_8
XFILLER_32_32 VDD VSS sg13g2_fill_2
XFILLER_20_180 VDD VSS sg13g2_decap_8
XFILLER_106_241 VDD VSS sg13g2_decap_8
XFILLER_107_775 VDD VSS sg13g2_decap_8
XFILLER_5_858 VDD VSS sg13g2_decap_8
XFILLER_79_114 VDD VSS sg13g2_decap_4
XFILLER_95_629 VDD VSS sg13g2_decap_8
XFILLER_0_585 VDD VSS sg13g2_decap_8
XFILLER_87_180 VDD VSS sg13g2_decap_8
XFILLER_36_718 VDD VSS sg13g2_decap_8
XFILLER_63_537 VDD VSS sg13g2_decap_8
XFILLER_75_386 VDD VSS sg13g2_decap_8
XFILLER_91_846 VDD VSS sg13g2_fill_2
XFILLER_91_835 VDD VSS sg13g2_decap_8
XFILLER_44_740 VDD VSS sg13g2_decap_8
XFILLER_91_857 VDD VSS sg13g2_decap_8
XFILLER_16_475 VDD VSS sg13g2_decap_8
XFILLER_32_924 VDD VSS sg13g2_fill_2
XFILLER_90_389 VDD VSS sg13g2_decap_8
XFILLER_31_412 VDD VSS sg13g2_decap_4
XFILLER_43_283 VDD VSS sg13g2_decap_8
XFILLER_73_94 VDD VSS sg13g2_fill_1
XFILLER_92_7 VDD VSS sg13g2_fill_1
XFILLER_31_445 VDD VSS sg13g2_decap_8
X_2770_ VSS VDD _4936_/Q _2771_/C _2770_/Y _2771_/B sg13g2_a21oi_1
X_4440_ _4440_/RESET_B VSS VDD _4440_/D _4440_/Q _4964_/CLK sg13g2_dfrbpq_1
X_4371_ _4371_/RESET_B VSS VDD _4371_/D _4371_/Q _4965_/CLK sg13g2_dfrbpq_1
XFILLER_99_924 VDD VSS sg13g2_fill_2
X_3322_ _4789_/Q _4790_/Q _3326_/C VDD VSS sg13g2_nor2_1
X_3253_ _3253_/Y _3253_/A _3253_/B VDD VSS sg13g2_xnor2_1
XFILLER_98_489 VDD VSS sg13g2_decap_8
XFILLER_100_439 VDD VSS sg13g2_fill_1
XFILLER_39_523 VDD VSS sg13g2_decap_4
XFILLER_67_821 VDD VSS sg13g2_decap_8
XFILLER_78_180 VDD VSS sg13g2_decap_8
XFILLER_85_117 VDD VSS sg13g2_decap_8
X_3184_ _3184_/B _3184_/C _3186_/B _3184_/Y VDD VSS sg13g2_nand3_1
XFILLER_14_0 VDD VSS sg13g2_decap_8
XFILLER_81_312 VDD VSS sg13g2_decap_8
XFILLER_94_695 VDD VSS sg13g2_decap_8
XFILLER_82_857 VDD VSS sg13g2_decap_8
XFILLER_35_762 VDD VSS sg13g2_fill_2
XFILLER_50_743 VDD VSS sg13g2_fill_2
XFILLER_62_581 VDD VSS sg13g2_fill_2
XFILLER_22_489 VDD VSS sg13g2_fill_1
X_2968_ _2968_/A0 _3021_/A1 _2979_/S _2968_/X VDD VSS sg13g2_mux2_1
X_4707_ fanout310/X VSS VDD _4707_/D _4707_/Q _4869_/CLK sg13g2_dfrbpq_1
XFILLER_108_539 VDD VSS sg13g2_decap_8
X_4638_ fanout252/X VSS VDD _4638_/D _4638_/Q clkload3/A sg13g2_dfrbpq_1
X_2899_ _2899_/A0 _3107_/A0 _2902_/S _4332_/D VDD VSS sg13g2_mux2_1
XFILLER_2_806 VDD VSS sg13g2_decap_8
Xhold630 _4807_/Q VDD VSS _3891_/B sg13g2_dlygate4sd3_1
XFILLER_116_561 VDD VSS sg13g2_decap_4
XFILLER_78_28 VDD VSS sg13g2_decap_4
Xhold663 _2797_/Y VDD VSS _4907_/D sg13g2_dlygate4sd3_1
Xhold652 _4247_/Y VDD VSS _4978_/D sg13g2_dlygate4sd3_1
Xhold641 _4220_/Y VDD VSS _4975_/D sg13g2_dlygate4sd3_1
X_4569_ fanout333/X VSS VDD _4569_/D _4569_/Q _4941_/CLK sg13g2_dfrbpq_1
XFILLER_89_412 VDD VSS sg13g2_decap_4
XFILLER_89_401 VDD VSS sg13g2_fill_1
XFILLER_116_594 VDD VSS sg13g2_decap_4
XFILLER_1_338 VDD VSS sg13g2_decap_8
Xhold696 _4238_/Y VDD VSS _4977_/D sg13g2_dlygate4sd3_1
Xhold685 _4969_/Q VDD VSS _4157_/B sg13g2_dlygate4sd3_1
Xhold674 _4634_/Q VDD VSS _3348_/B sg13g2_dlygate4sd3_1
XFILLER_104_767 VDD VSS sg13g2_decap_8
XFILLER_58_821 VDD VSS sg13g2_decap_8
XFILLER_76_128 VDD VSS sg13g2_fill_2
XFILLER_58_876 VDD VSS sg13g2_decap_8
Xhold1330 _4779_/Q VDD VSS _2325_/A sg13g2_dlygate4sd3_1
Xhold1341 _2436_/Y VDD VSS _4916_/D sg13g2_dlygate4sd3_1
Xhold1352 _4658_/Q VDD VSS _3439_/A sg13g2_dlygate4sd3_1
XFILLER_91_109 VDD VSS sg13g2_decap_8
XFILLER_73_835 VDD VSS sg13g2_decap_8
Xhold1363 _3428_/Y VDD VSS _4651_/D sg13g2_dlygate4sd3_1
Xhold1374 _4865_/Q VDD VSS _3522_/C sg13g2_dlygate4sd3_1
Xhold1385 _4860_/Q VDD VSS _3504_/A sg13g2_dlygate4sd3_1
XFILLER_85_684 VDD VSS sg13g2_decap_4
XFILLER_84_194 VDD VSS sg13g2_decap_8
Xhold1396 _3853_/Y VDD VSS _4791_/D sg13g2_dlygate4sd3_1
XFILLER_60_518 VDD VSS sg13g2_decap_4
XFILLER_53_570 VDD VSS sg13g2_fill_1
XFILLER_43_86 VDD VSS sg13g2_decap_8
XFILLER_43_97 VDD VSS sg13g2_fill_2
X_4403__523 VDD VSS _4403_/RESET_B sg13g2_tiehi
XFILLER_4_110 VDD VSS sg13g2_decap_8
XFILLER_107_550 VDD VSS sg13g2_decap_8
XFILLER_4_14 VDD VSS sg13g2_decap_8
XFILLER_4_176 VDD VSS sg13g2_decap_8
XFILLER_96_905 VDD VSS sg13g2_decap_8
XFILLER_110_704 VDD VSS sg13g2_decap_8
XFILLER_68_618 VDD VSS sg13g2_fill_1
XFILLER_0_382 VDD VSS sg13g2_decap_8
XFILLER_110_726 VDD VSS sg13g2_decap_8
XFILLER_1_894 VDD VSS sg13g2_decap_8
XFILLER_49_843 VDD VSS sg13g2_decap_8
XFILLER_76_651 VDD VSS sg13g2_decap_8
XFILLER_36_504 VDD VSS sg13g2_decap_8
XFILLER_48_364 VDD VSS sg13g2_decap_8
XFILLER_63_301 VDD VSS sg13g2_decap_8
XFILLER_64_824 VDD VSS sg13g2_decap_8
XFILLER_91_610 VDD VSS sg13g2_decap_8
X_4410__516 VDD VSS _4410_/RESET_B sg13g2_tiehi
X_3940_ VSS VDD _2249_/Y _3939_/Y _3940_/Y _3938_/Y sg13g2_a21oi_1
XFILLER_91_698 VDD VSS sg13g2_fill_1
XFILLER_91_687 VDD VSS sg13g2_decap_8
XFILLER_90_197 VDD VSS sg13g2_decap_8
XFILLER_20_916 VDD VSS sg13g2_decap_8
XFILLER_32_765 VDD VSS sg13g2_decap_8
X_3871_ _3871_/A _3948_/C _3871_/Y VDD VSS sg13g2_nor2_1
X_2822_ _2849_/C _4856_/Q _2983_/A VDD VSS _4794_/Q sg13g2_nand3b_1
X_2753_ VSS VDD _2754_/A1 _2752_/C _2753_/Y _2749_/A sg13g2_a21oi_1
X_2684_ _4717_/Q _3563_/B _2685_/D VDD VSS sg13g2_nor2b_1
X_4423_ _4423_/RESET_B VSS VDD _4423_/D _4423_/Q _4967_/CLK sg13g2_dfrbpq_1
X_4354_ _4354_/RESET_B VSS VDD _4354_/D _4354_/Q _4552_/CLK sg13g2_dfrbpq_1
X_3305_ _4647_/Q _4648_/Q _3493_/A _3408_/A VDD VSS sg13g2_or3_1
XFILLER_58_117 VDD VSS sg13g2_fill_1
X_4285_ _4285_/RESET_B VSS VDD _4285_/D _4285_/Q _4959_/CLK sg13g2_dfrbpq_1
XFILLER_55_802 VDD VSS sg13g2_decap_8
X_3236_ _2603_/B VDD _3236_/Y VSS _4599_/Q _3234_/B sg13g2_o21ai_1
XFILLER_86_459 VDD VSS sg13g2_decap_8
XFILLER_39_386 VDD VSS sg13g2_decap_8
X_3167_ _3167_/Y _3167_/A _3167_/B VDD VSS sg13g2_xnor2_1
XFILLER_94_481 VDD VSS sg13g2_fill_2
XFILLER_27_537 VDD VSS sg13g2_decap_8
XFILLER_54_334 VDD VSS sg13g2_decap_8
XFILLER_55_868 VDD VSS sg13g2_decap_8
X_3098_ _3098_/A0 hold872/X _3109_/S _4522_/D VDD VSS sg13g2_mux2_1
XFILLER_70_838 VDD VSS sg13g2_decap_8
XFILLER_81_142 VDD VSS sg13g2_decap_8
XFILLER_82_687 VDD VSS sg13g2_decap_4
XFILLER_35_570 VDD VSS sg13g2_decap_8
XFILLER_22_220 VDD VSS sg13g2_decap_8
XFILLER_23_754 VDD VSS sg13g2_decap_8
Xfanout24 _2625_/Y _3791_/S VDD VSS sg13g2_buf_1
Xfanout35 _2391_/Y _2813_/A VDD VSS sg13g2_buf_1
Xfanout46 _3483_/C _3490_/S VDD VSS sg13g2_buf_1
XFILLER_22_286 VDD VSS sg13g2_decap_8
XFILLER_50_595 VDD VSS sg13g2_decap_4
Xfanout57 _2431_/Y _2805_/B VDD VSS sg13g2_buf_1
Xfanout68 _3867_/X _3911_/B VDD VSS sg13g2_buf_1
Xfanout79 _3009_/Y _3028_/S VDD VSS sg13g2_buf_1
XFILLER_109_804 VDD VSS sg13g2_decap_8
XFILLER_10_437 VDD VSS sg13g2_decap_8
XFILLER_13_45 VDD VSS sg13g2_fill_1
XFILLER_109_837 VDD VSS sg13g2_fill_2
XFILLER_109_848 VDD VSS sg13g2_decap_8
XFILLER_116_380 VDD VSS sg13g2_decap_8
XFILLER_1_135 VDD VSS sg13g2_decap_8
XFILLER_49_139 VDD VSS sg13g2_fill_1
XFILLER_77_426 VDD VSS sg13g2_fill_1
XFILLER_89_286 VDD VSS sg13g2_decap_8
XFILLER_38_42 VDD VSS sg13g2_decap_8
XFILLER_45_301 VDD VSS sg13g2_fill_1
Xhold1160 _4301_/Q VDD VSS _2866_/A0 sg13g2_dlygate4sd3_1
Xhold1171 _4347_/Q VDD VSS _2915_/A0 sg13g2_dlygate4sd3_1
Xhold1182 _4399_/Q VDD VSS _4144_/A1 sg13g2_dlygate4sd3_1
Xhold1193 _4297_/Q VDD VSS _2862_/A0 sg13g2_dlygate4sd3_1
XFILLER_85_492 VDD VSS sg13g2_fill_2
XFILLER_33_507 VDD VSS sg13g2_decap_4
XFILLER_73_676 VDD VSS sg13g2_fill_1
XFILLER_14_732 VDD VSS sg13g2_decap_8
XFILLER_14_743 VDD VSS sg13g2_fill_1
XFILLER_14_798 VDD VSS sg13g2_decap_8
XFILLER_110_91 VDD VSS sg13g2_decap_8
XFILLER_13_286 VDD VSS sg13g2_decap_8
XFILLER_70_51 VDD VSS sg13g2_decap_8
XFILLER_70_62 VDD VSS sg13g2_fill_2
XFILLER_9_235 VDD VSS sg13g2_decap_8
Xclkload16 VDD clkload16/Y _4737_/CLK VSS sg13g2_inv_1
XFILLER_5_430 VDD VSS sg13g2_decap_8
Xclkload27 _4977_/CLK clkload27/X VDD VSS sg13g2_buf_8
Xclkload38 VDD clkload38/Y _4979_/CLK VSS sg13g2_inv_1
XFILLER_115_818 VDD VSS sg13g2_decap_8
XFILLER_55_7 VDD VSS sg13g2_decap_8
XFILLER_108_892 VDD VSS sg13g2_fill_1
XFILLER_68_404 VDD VSS sg13g2_decap_8
XFILLER_79_93 VDD VSS sg13g2_decap_8
XFILLER_96_746 VDD VSS sg13g2_decap_4
XFILLER_95_201 VDD VSS sg13g2_decap_8
XFILLER_110_545 VDD VSS sg13g2_fill_2
XFILLER_1_691 VDD VSS sg13g2_decap_8
X_4070_ _4267_/Q _4292_/Q _4118_/S _4070_/X VDD VSS sg13g2_mux2_1
XFILLER_36_301 VDD VSS sg13g2_decap_8
XFILLER_49_673 VDD VSS sg13g2_decap_8
X_3021_ hold971/X _3021_/A1 _3029_/S _3021_/X VDD VSS sg13g2_mux2_1
XFILLER_37_857 VDD VSS sg13g2_decap_8
XFILLER_76_492 VDD VSS sg13g2_decap_8
XFILLER_64_665 VDD VSS sg13g2_decap_8
X_4972_ fanout324/X VSS VDD _4972_/D _4972_/Q _4972_/CLK sg13g2_dfrbpq_1
X_3923_ _3923_/A _3923_/B _4814_/D VDD VSS sg13g2_nor2_1
XFILLER_32_562 VDD VSS sg13g2_decap_8
XFILLER_60_871 VDD VSS sg13g2_decap_8
XFILLER_60_882 VDD VSS sg13g2_fill_2
X_3854_ _4773_/Q VDD _3854_/Y VSS _4772_/Q _3851_/B sg13g2_o21ai_1
XFILLER_20_768 VDD VSS sg13g2_decap_8
XFILLER_81_0 VDD VSS sg13g2_decap_8
X_2805_ _4911_/D _2809_/A _2805_/B _2805_/C VDD VSS sg13g2_and3_1
X_3785_ _3785_/A _3785_/B _4772_/D VDD VSS sg13g2_and2_1
X_2736_ _2735_/Y VDD _2737_/A VSS _2739_/A _2739_/C sg13g2_o21ai_1
X_2667_ VSS VDD _2330_/A _4697_/Q _2667_/Y _4685_/Q sg13g2_a21oi_1
X_4406_ _4406_/RESET_B VSS VDD _4406_/D _4406_/Q _4976_/CLK sg13g2_dfrbpq_1
Xfanout203 _4787_/Q _3413_/C VDD VSS sg13g2_buf_1
Xfanout214 hold564/X _3528_/A VDD VSS sg13g2_buf_1
X_2598_ _4595_/Q _2598_/B _3224_/B _3229_/B VDD VSS sg13g2_or3_1
XFILLER_99_551 VDD VSS sg13g2_decap_8
XFILLER_113_383 VDD VSS sg13g2_decap_8
XFILLER_115_14 VDD VSS sg13g2_decap_8
Xfanout225 hold811/X _3106_/A0 VDD VSS sg13g2_buf_1
Xfanout236 hold1145/X _3095_/A0 VDD VSS sg13g2_buf_1
Xfanout247 fanout248/X fanout247/X VDD VSS sg13g2_buf_1
X_4337_ _4337_/RESET_B VSS VDD _4337_/D _4337_/Q _4559_/CLK sg13g2_dfrbpq_1
XFILLER_101_534 VDD VSS sg13g2_decap_8
XFILLER_75_919 VDD VSS sg13g2_decap_8
Xfanout258 fanout260/X fanout258/X VDD VSS sg13g2_buf_1
Xfanout269 fanout274/X fanout269/X VDD VSS sg13g2_buf_1
X_4268_ _4268_/RESET_B VSS VDD _4268_/D _4268_/Q clkload6/A sg13g2_dfrbpq_1
XFILLER_87_768 VDD VSS sg13g2_decap_8
XFILLER_28_813 VDD VSS sg13g2_decap_8
X_3219_ _2596_/B VDD _3219_/Y VSS _3217_/A _3217_/B sg13g2_o21ai_1
XFILLER_86_289 VDD VSS sg13g2_fill_2
XFILLER_27_312 VDD VSS sg13g2_fill_2
XFILLER_39_172 VDD VSS sg13g2_decap_4
XFILLER_55_632 VDD VSS sg13g2_decap_8
X_4199_ VSS VDD _4199_/A1 _4197_/X _4199_/Y _4198_/Y sg13g2_a21oi_1
XFILLER_43_816 VDD VSS sg13g2_decap_8
XFILLER_55_665 VDD VSS sg13g2_fill_2
XFILLER_55_676 VDD VSS sg13g2_decap_8
XFILLER_70_602 VDD VSS sg13g2_decap_8
XFILLER_82_440 VDD VSS sg13g2_fill_1
XFILLER_15_529 VDD VSS sg13g2_decap_8
XFILLER_42_326 VDD VSS sg13g2_fill_1
XFILLER_42_337 VDD VSS sg13g2_decap_4
XFILLER_82_484 VDD VSS sg13g2_decap_4
XFILLER_91_28 VDD VSS sg13g2_decap_8
XFILLER_10_212 VDD VSS sg13g2_fill_2
XFILLER_10_245 VDD VSS sg13g2_decap_8
XFILLER_6_205 VDD VSS sg13g2_decap_8
XFILLER_109_634 VDD VSS sg13g2_decap_8
XFILLER_3_912 VDD VSS sg13g2_decap_8
X_4400__526 VDD VSS _4400_/RESET_B sg13g2_tiehi
XFILLER_2_422 VDD VSS sg13g2_decap_8
XFILLER_104_372 VDD VSS sg13g2_decap_8
XFILLER_49_63 VDD VSS sg13g2_decap_8
XFILLER_77_201 VDD VSS sg13g2_decap_8
XFILLER_18_301 VDD VSS sg13g2_decap_8
XFILLER_19_802 VDD VSS sg13g2_decap_4
XFILLER_46_632 VDD VSS sg13g2_decap_8
XFILLER_46_643 VDD VSS sg13g2_fill_1
XFILLER_92_248 VDD VSS sg13g2_decap_8
XFILLER_18_356 VDD VSS sg13g2_decap_8
XFILLER_19_868 VDD VSS sg13g2_decap_8
XFILLER_65_84 VDD VSS sg13g2_decap_8
XFILLER_73_440 VDD VSS sg13g2_fill_2
XFILLER_92_259 VDD VSS sg13g2_fill_2
XFILLER_33_304 VDD VSS sg13g2_fill_2
XFILLER_33_315 VDD VSS sg13g2_fill_1
XFILLER_45_175 VDD VSS sg13g2_decap_8
XFILLER_60_123 VDD VSS sg13g2_decap_8
XFILLER_14_551 VDD VSS sg13g2_decap_8
XFILLER_42_871 VDD VSS sg13g2_decap_8
X_3570_ _3570_/A _3596_/A _3571_/A VDD VSS sg13g2_nor2b_1
X_2521_ _4650_/D _3369_/S _2402_/B VDD VSS sg13g2_nand2b_1
XFILLER_114_103 VDD VSS sg13g2_decap_8
XFILLER_115_648 VDD VSS sg13g2_decap_8
XFILLER_114_169 VDD VSS sg13g2_decap_8
XFILLER_69_702 VDD VSS sg13g2_decap_8
X_2452_ VSS VDD _2645_/A _3626_/A _4857_/D _2451_/Y sg13g2_a21oi_1
XFILLER_111_821 VDD VSS sg13g2_decap_8
XFILLER_69_746 VDD VSS sg13g2_decap_8
X_2383_ _4649_/Q VDD _2388_/C VSS _4664_/Q _4656_/Q sg13g2_o21ai_1
XFILLER_111_843 VDD VSS sg13g2_decap_8
X_4122_ _4121_/Y VDD _4122_/Y VSS _4121_/A _2353_/Y sg13g2_o21ai_1
XFILLER_84_738 VDD VSS sg13g2_decap_8
X_4053_ _4253_/A1 VDD _4053_/Y VSS _4250_/A1 _4053_/A2 sg13g2_o21ai_1
XFILLER_36_120 VDD VSS sg13g2_decap_8
XFILLER_37_632 VDD VSS sg13g2_decap_8
XFILLER_77_790 VDD VSS sg13g2_decap_8
Xinput3 replay_req input3/X VDD VSS sg13g2_buf_1
X_3004_ _3004_/A0 _3106_/A0 _3007_/S _4431_/D VDD VSS sg13g2_mux2_1
XFILLER_36_131 VDD VSS sg13g2_fill_1
XFILLER_36_164 VDD VSS sg13g2_fill_1
XFILLER_24_359 VDD VSS sg13g2_fill_2
X_4955_ fanout328/X VSS VDD _4955_/D _4955_/Q _4955_/CLK sg13g2_dfrbpq_1
XFILLER_51_167 VDD VSS sg13g2_fill_1
XFILLER_51_189 VDD VSS sg13g2_fill_2
X_3906_ _3906_/Y _3905_/Y _3901_/B _3904_/B _3879_/D VDD VSS sg13g2_a22oi_1
X_4886_ fanout309/X VSS VDD _4886_/D _4886_/Q _4894_/CLK sg13g2_dfrbpq_1
X_3837_ _4786_/D _3837_/B1 _3836_/Y _3837_/A2 _2313_/Y VDD VSS sg13g2_a22oi_1
XFILLER_20_598 VDD VSS sg13g2_fill_2
X_3768_ _3768_/Y _3768_/A _3770_/C VDD VSS sg13g2_xnor2_1
XFILLER_106_615 VDD VSS sg13g2_decap_8
X_2719_ _2719_/Y _3144_/A _2718_/Y _2582_/A _4623_/Q VDD VSS sg13g2_a22oi_1
XFILLER_105_125 VDD VSS sg13g2_decap_8
X_3699_ VSS VDD _3697_/Y _3698_/Y _3703_/B _3719_/A sg13g2_a21oi_1
XFILLER_105_136 VDD VSS sg13g2_fill_1
XFILLER_102_810 VDD VSS sg13g2_decap_8
XFILLER_102_821 VDD VSS sg13g2_decap_8
XFILLER_59_212 VDD VSS sg13g2_fill_2
XFILLER_87_554 VDD VSS sg13g2_fill_2
XFILLER_75_705 VDD VSS sg13g2_decap_8
XFILLER_101_386 VDD VSS sg13g2_decap_8
XFILLER_74_215 VDD VSS sg13g2_decap_8
XFILLER_74_248 VDD VSS sg13g2_decap_8
XFILLER_27_142 VDD VSS sg13g2_decap_4
XFILLER_27_153 VDD VSS sg13g2_fill_1
XFILLER_28_676 VDD VSS sg13g2_decap_8
XFILLER_43_602 VDD VSS sg13g2_decap_8
XFILLER_55_462 VDD VSS sg13g2_decap_8
XFILLER_83_771 VDD VSS sg13g2_decap_8
XFILLER_27_186 VDD VSS sg13g2_fill_2
XFILLER_42_178 VDD VSS sg13g2_decap_8
XFILLER_43_679 VDD VSS sg13g2_decap_8
X_4324__402 VDD VSS _4324_/RESET_B sg13g2_tiehi
XFILLER_109_475 VDD VSS sg13g2_decap_8
XFILLER_111_106 VDD VSS sg13g2_decap_8
XFILLER_3_786 VDD VSS sg13g2_decap_8
XFILLER_39_908 VDD VSS sg13g2_decap_8
XFILLER_78_554 VDD VSS sg13g2_decap_8
XFILLER_93_513 VDD VSS sg13g2_decap_8
XFILLER_93_502 VDD VSS sg13g2_fill_2
XFILLER_18_7 VDD VSS sg13g2_decap_8
XFILLER_59_790 VDD VSS sg13g2_decap_8
XFILLER_93_546 VDD VSS sg13g2_decap_8
XFILLER_74_760 VDD VSS sg13g2_fill_2
XFILLER_81_719 VDD VSS sg13g2_decap_4
XFILLER_34_635 VDD VSS sg13g2_decap_8
XFILLER_62_911 VDD VSS sg13g2_decap_8
XFILLER_73_292 VDD VSS sg13g2_fill_1
XFILLER_33_156 VDD VSS sg13g2_decap_8
XFILLER_21_329 VDD VSS sg13g2_decap_8
XFILLER_61_498 VDD VSS sg13g2_decap_8
X_4740_ fanout273/X VSS VDD _4740_/D _4740_/Q _4749_/CLK sg13g2_dfrbpq_1
X_4671_ fanout268/X VSS VDD _4671_/D _4671_/Q _4745_/CLK sg13g2_dfrbpq_1
X_3622_ _3622_/A0 _4629_/Q _3653_/S _3622_/X VDD VSS sg13g2_mux2_1
X_3553_ _3553_/A0 _3553_/A1 _3553_/S _4715_/D VDD VSS sg13g2_mux2_1
XFILLER_115_467 VDD VSS sg13g2_decap_8
XFILLER_44_0 VDD VSS sg13g2_decap_8
X_3484_ _3483_/Y VDD _4679_/D VSS _2285_/Y _3481_/C sg13g2_o21ai_1
X_2504_ VSS VDD _3156_/B _3154_/B _3154_/A sg13g2_or2_1
XFILLER_89_808 VDD VSS sg13g2_decap_8
X_2435_ VSS VDD _2392_/C _2438_/B _2435_/Y _2807_/A sg13g2_a21oi_1
X_4105_ _4370_/Q _4395_/Q _4197_/S _4105_/X VDD VSS sg13g2_mux2_1
X_2366_ _2388_/A _4679_/Q _4671_/Q VDD VSS sg13g2_xnor2_1
XFILLER_97_885 VDD VSS sg13g2_fill_2
XFILLER_69_598 VDD VSS sg13g2_decap_8
X_2297_ VDD _3820_/A _3796_/B VSS sg13g2_inv_1
XFILLER_96_384 VDD VSS sg13g2_decap_8
X_4036_ _4035_/Y VDD _4957_/D VSS _4033_/Y _4034_/Y sg13g2_o21ai_1
XFILLER_53_911 VDD VSS sg13g2_decap_8
XFILLER_52_443 VDD VSS sg13g2_fill_1
XFILLER_80_730 VDD VSS sg13g2_decap_8
XFILLER_24_145 VDD VSS sg13g2_decap_8
XFILLER_12_329 VDD VSS sg13g2_fill_1
X_4938_ fanout334/X VSS VDD _4938_/D _4938_/Q _4941_/CLK sg13g2_dfrbpq_1
X_4869_ fanout326/X VSS VDD _4869_/D _4869_/Q _4869_/CLK sg13g2_dfrbpq_1
XFILLER_21_885 VDD VSS sg13g2_fill_2
XFILLER_107_924 VDD VSS sg13g2_fill_2
XFILLER_21_34 VDD VSS sg13g2_decap_8
XFILLER_21_78 VDD VSS sg13g2_decap_8
XFILLER_4_539 VDD VSS sg13g2_decap_8
XFILLER_88_863 VDD VSS sg13g2_decap_8
XFILLER_0_767 VDD VSS sg13g2_decap_8
XFILLER_101_172 VDD VSS sg13g2_decap_8
XFILLER_63_708 VDD VSS sg13g2_decap_8
XFILLER_15_101 VDD VSS sg13g2_decap_4
XFILLER_28_462 VDD VSS sg13g2_decap_8
XFILLER_43_410 VDD VSS sg13g2_decap_8
XFILLER_46_53 VDD VSS sg13g2_decap_8
XFILLER_56_782 VDD VSS sg13g2_decap_4
XFILLER_62_207 VDD VSS sg13g2_decap_8
XFILLER_15_123 VDD VSS sg13g2_decap_8
XFILLER_55_281 VDD VSS sg13g2_decap_8
XFILLER_102_70 VDD VSS sg13g2_decap_8
XFILLER_71_763 VDD VSS sg13g2_decap_4
XFILLER_24_690 VDD VSS sg13g2_decap_8
XFILLER_30_104 VDD VSS sg13g2_decap_8
XFILLER_12_874 VDD VSS sg13g2_decap_8
XFILLER_62_74 VDD VSS sg13g2_decap_4
XFILLER_7_333 VDD VSS sg13g2_decap_8
XFILLER_8_834 VDD VSS sg13g2_decap_8
XFILLER_7_47 VDD VSS sg13g2_decap_8
XFILLER_7_377 VDD VSS sg13g2_fill_2
XFILLER_7_399 VDD VSS sg13g2_fill_2
XFILLER_98_627 VDD VSS sg13g2_decap_8
XFILLER_87_60 VDD VSS sg13g2_decap_8
XFILLER_94_800 VDD VSS sg13g2_decap_8
XFILLER_87_93 VDD VSS sg13g2_decap_8
XFILLER_38_237 VDD VSS sg13g2_fill_2
XFILLER_94_877 VDD VSS sg13g2_decap_8
XFILLER_22_605 VDD VSS sg13g2_decap_8
XFILLER_61_273 VDD VSS sg13g2_decap_8
X_2984_ _2984_/A0 _3086_/A0 _3008_/S _4411_/D VDD VSS sg13g2_mux2_1
X_4723_ fanout327/X VSS VDD _4723_/D _4723_/Q _4870_/CLK sg13g2_dfrbpq_1
X_4654_ fanout263/X VSS VDD _4654_/D _4654_/Q _4673_/CLK sg13g2_dfrbpq_1
Xhold812 _4661_/Q VDD VSS _3445_/A sg13g2_dlygate4sd3_1
Xhold801 _3875_/Y VDD VSS _4801_/D sg13g2_dlygate4sd3_1
X_4585_ fanout279/X VSS VDD _4585_/D _4585_/Q _4946_/CLK sg13g2_dfrbpq_1
X_3605_ _3601_/Y VDD _4726_/D VSS _3562_/Y _3604_/X sg13g2_o21ai_1
XFILLER_116_754 VDD VSS sg13g2_decap_8
Xhold845 _4525_/Q VDD VSS hold845/X sg13g2_dlygate4sd3_1
Xhold834 _4363_/Q VDD VSS hold834/X sg13g2_dlygate4sd3_1
Xhold823 _4531_/Q VDD VSS hold823/X sg13g2_dlygate4sd3_1
X_3536_ _3536_/A0 _3536_/A1 _3551_/S _4698_/D VDD VSS sg13g2_mux2_1
XFILLER_89_605 VDD VSS sg13g2_decap_8
XFILLER_103_415 VDD VSS sg13g2_decap_8
XFILLER_115_264 VDD VSS sg13g2_decap_8
Xhold889 _4486_/Q VDD VSS hold889/X sg13g2_dlygate4sd3_1
Xhold878 _4349_/Q VDD VSS hold878/X sg13g2_dlygate4sd3_1
Xhold867 _4385_/Q VDD VSS hold867/X sg13g2_dlygate4sd3_1
Xhold856 _4380_/Q VDD VSS hold856/X sg13g2_dlygate4sd3_1
XFILLER_88_104 VDD VSS sg13g2_decap_8
XFILLER_103_459 VDD VSS sg13g2_fill_1
X_3467_ _3483_/B _3477_/C _3467_/A _3467_/Y VDD VSS sg13g2_nand3_1
XFILLER_69_362 VDD VSS sg13g2_decap_8
Xhold1501 _4921_/Q VDD VSS _2812_/A sg13g2_dlygate4sd3_1
X_3398_ _4783_/Q _3411_/B _3398_/C _3398_/D _3400_/A VDD VSS sg13g2_nor4_1
X_2418_ _2419_/D _2806_/A _2418_/B VDD VSS sg13g2_nand2_1
XFILLER_29_226 VDD VSS sg13g2_decap_8
Xhold1512 _3762_/Y VDD VSS _4766_/D sg13g2_dlygate4sd3_1
Xhold1523 _2740_/Y VDD VSS _2741_/B sg13g2_dlygate4sd3_1
Xhold1534 _4911_/Q VDD VSS _2431_/A sg13g2_dlygate4sd3_1
X_2349_ VDD _2419_/A _2410_/A VSS sg13g2_inv_1
XFILLER_57_557 VDD VSS sg13g2_decap_8
Xhold1545 _4746_/Q VDD VSS _3651_/A0 sg13g2_dlygate4sd3_1
Xhold1556 _4652_/Q VDD VSS _3297_/A0 sg13g2_dlygate4sd3_1
Xhold1567 _2545_/X VDD VSS _4876_/D sg13g2_dlygate4sd3_1
X_4314__412 VDD VSS _4314_/RESET_B sg13g2_tiehi
XFILLER_96_192 VDD VSS sg13g2_decap_8
XFILLER_44_229 VDD VSS sg13g2_decap_8
XFILLER_72_516 VDD VSS sg13g2_decap_8
Xhold1578 _4924_/Q VDD VSS _2413_/A sg13g2_dlygate4sd3_1
Xhold1589 _4572_/Q VDD VSS _2510_/B sg13g2_dlygate4sd3_1
X_4019_ _4362_/Q _4387_/Q _4052_/A _4019_/X VDD VSS sg13g2_mux2_1
XFILLER_85_899 VDD VSS sg13g2_decap_8
XFILLER_37_281 VDD VSS sg13g2_decap_8
XFILLER_65_590 VDD VSS sg13g2_decap_8
XFILLER_25_454 VDD VSS sg13g2_decap_8
XFILLER_52_262 VDD VSS sg13g2_decap_4
XFILLER_12_115 VDD VSS sg13g2_decap_8
XFILLER_12_126 VDD VSS sg13g2_fill_2
XFILLER_13_627 VDD VSS sg13g2_decap_8
XFILLER_12_137 VDD VSS sg13g2_decap_4
XFILLER_12_159 VDD VSS sg13g2_decap_8
XFILLER_8_119 VDD VSS sg13g2_fill_2
XFILLER_107_710 VDD VSS sg13g2_fill_2
XFILLER_32_99 VDD VSS sg13g2_decap_8
XFILLER_4_303 VDD VSS sg13g2_fill_2
XFILLER_5_837 VDD VSS sg13g2_decap_8
X_4321__405 VDD VSS _4321_/RESET_B sg13g2_tiehi
XFILLER_106_231 VDD VSS sg13g2_decap_4
XFILLER_107_754 VDD VSS sg13g2_decap_8
XFILLER_79_148 VDD VSS sg13g2_decap_8
XFILLER_0_564 VDD VSS sg13g2_decap_8
XFILLER_48_524 VDD VSS sg13g2_fill_1
XFILLER_75_321 VDD VSS sg13g2_decap_8
XFILLER_57_96 VDD VSS sg13g2_decap_8
XFILLER_91_814 VDD VSS sg13g2_fill_2
XFILLER_16_410 VDD VSS sg13g2_decap_8
XFILLER_90_335 VDD VSS sg13g2_decap_8
XFILLER_16_443 VDD VSS sg13g2_decap_4
XFILLER_16_454 VDD VSS sg13g2_decap_8
XFILLER_43_240 VDD VSS sg13g2_fill_2
XFILLER_90_368 VDD VSS sg13g2_decap_8
XFILLER_43_262 VDD VSS sg13g2_decap_8
XFILLER_71_582 VDD VSS sg13g2_decap_8
XFILLER_85_7 VDD VSS sg13g2_decap_8
XFILLER_7_163 VDD VSS sg13g2_decap_4
X_4370_ _4370_/RESET_B VSS VDD _4370_/D _4370_/Q _4964_/CLK sg13g2_dfrbpq_1
X_3321_ _4792_/Q _4793_/Q _4791_/Q _3406_/A VDD VSS sg13g2_nor3_1
XFILLER_112_267 VDD VSS sg13g2_decap_8
XFILLER_67_800 VDD VSS sg13g2_decap_8
XFILLER_79_660 VDD VSS sg13g2_fill_1
X_3252_ VSS VDD _3278_/A _3252_/A2 _4606_/D _3289_/A sg13g2_a21oi_1
XFILLER_98_468 VDD VSS sg13g2_decap_8
X_3183_ _3183_/B1 VDD _3184_/C VSS _3181_/A _3181_/B sg13g2_o21ai_1
XFILLER_26_218 VDD VSS sg13g2_decap_8
XFILLER_82_814 VDD VSS sg13g2_decap_8
XFILLER_19_292 VDD VSS sg13g2_decap_8
XFILLER_35_741 VDD VSS sg13g2_decap_8
XFILLER_23_925 VDD VSS sg13g2_fill_1
XFILLER_35_796 VDD VSS sg13g2_fill_1
XFILLER_50_722 VDD VSS sg13g2_decap_8
XFILLER_90_891 VDD VSS sg13g2_fill_1
XFILLER_90_880 VDD VSS sg13g2_decap_8
XFILLER_22_468 VDD VSS sg13g2_decap_8
XFILLER_50_755 VDD VSS sg13g2_decap_8
XFILLER_50_766 VDD VSS sg13g2_fill_2
XFILLER_22_479 VDD VSS sg13g2_fill_1
X_2967_ _2967_/A0 _3096_/A0 _2975_/S _2967_/X VDD VSS sg13g2_mux2_1
X_4706_ fanout308/X VSS VDD _4706_/D _4706_/Q _4978_/CLK sg13g2_dfrbpq_1
X_2898_ _2898_/A0 _3106_/A0 _2902_/S _4331_/D VDD VSS sg13g2_mux2_1
XFILLER_108_518 VDD VSS sg13g2_decap_8
X_4637_ fanout251/X VSS VDD _4637_/D _4637_/Q clkload3/A sg13g2_dfrbpq_1
XFILLER_116_540 VDD VSS sg13g2_decap_8
Xhold620 _4835_/Q VDD VSS _3993_/A sg13g2_dlygate4sd3_1
XFILLER_116_573 VDD VSS sg13g2_decap_8
Xhold631 _3892_/Y VDD VSS _4807_/D sg13g2_dlygate4sd3_1
Xhold653 _4976_/Q VDD VSS _4228_/B sg13g2_dlygate4sd3_1
Xhold642 _4559_/Q VDD VSS _3142_/A sg13g2_dlygate4sd3_1
X_4568_ fanout333/X VSS VDD _4568_/D _4568_/Q _4941_/CLK sg13g2_dfrbpq_1
XFILLER_1_317 VDD VSS sg13g2_decap_8
Xhold697 _4832_/Q VDD VSS _3981_/A sg13g2_dlygate4sd3_1
Xhold686 _4158_/Y VDD VSS _4969_/D sg13g2_dlygate4sd3_1
Xhold675 _4940_/Q VDD VSS _2780_/B sg13g2_dlygate4sd3_1
Xhold664 _4958_/Q VDD VSS _4044_/B sg13g2_dlygate4sd3_1
X_4499_ fanout304/X VSS VDD _4499_/D _4499_/Q _4974_/CLK sg13g2_dfrbpq_1
X_3519_ _3519_/A _3519_/B _3519_/X VDD VSS sg13g2_and2_1
XFILLER_58_800 VDD VSS sg13g2_decap_8
XFILLER_58_855 VDD VSS sg13g2_decap_8
XFILLER_73_803 VDD VSS sg13g2_decap_8
Xhold1320 _2750_/Y VDD VSS _2752_/B sg13g2_dlygate4sd3_1
Xhold1331 _3816_/Y VDD VSS _4779_/D sg13g2_dlygate4sd3_1
Xhold1342 _4822_/Q VDD VSS _3955_/A sg13g2_dlygate4sd3_1
XFILLER_97_490 VDD VSS sg13g2_decap_8
XFILLER_94_28 VDD VSS sg13g2_decap_8
XFILLER_85_663 VDD VSS sg13g2_decap_8
XFILLER_57_387 VDD VSS sg13g2_decap_4
XFILLER_84_173 VDD VSS sg13g2_decap_8
Xhold1353 _4515_/Q VDD VSS hold1353/X sg13g2_dlygate4sd3_1
Xhold1364 _4683_/Q VDD VSS _2328_/A sg13g2_dlygate4sd3_1
Xhold1375 _2696_/Y VDD VSS _4865_/D sg13g2_dlygate4sd3_1
Xhold1386 _4545_/Q VDD VSS _3121_/A1 sg13g2_dlygate4sd3_1
XFILLER_27_77 VDD VSS sg13g2_decap_8
XFILLER_45_549 VDD VSS sg13g2_decap_8
Xhold1397 _4638_/Q VDD VSS _3361_/A sg13g2_dlygate4sd3_1
XFILLER_14_914 VDD VSS sg13g2_decap_8
XFILLER_72_357 VDD VSS sg13g2_fill_1
XFILLER_72_379 VDD VSS sg13g2_decap_8
XFILLER_14_925 VDD VSS sg13g2_fill_1
XFILLER_43_21 VDD VSS sg13g2_fill_1
XFILLER_13_446 VDD VSS sg13g2_fill_1
XFILLER_41_777 VDD VSS sg13g2_decap_8
XFILLER_43_65 VDD VSS sg13g2_decap_8
XFILLER_40_287 VDD VSS sg13g2_decap_8
XFILLER_40_298 VDD VSS sg13g2_fill_2
Xclkbuf_leaf_20_clk clkbuf_4_7_0_clk/X _4927_/CLK VDD VSS sg13g2_buf_8
XFILLER_5_623 VDD VSS sg13g2_fill_2
XFILLER_111_0 VDD VSS sg13g2_decap_8
XFILLER_0_361 VDD VSS sg13g2_decap_8
XFILLER_1_873 VDD VSS sg13g2_decap_8
XFILLER_49_822 VDD VSS sg13g2_decap_8
XFILLER_68_95 VDD VSS sg13g2_decap_8
XFILLER_48_343 VDD VSS sg13g2_decap_8
XFILLER_88_490 VDD VSS sg13g2_decap_8
XFILLER_49_899 VDD VSS sg13g2_decap_8
XFILLER_75_184 VDD VSS sg13g2_decap_8
XFILLER_84_61 VDD VSS sg13g2_fill_2
XFILLER_90_132 VDD VSS sg13g2_fill_2
XFILLER_63_379 VDD VSS sg13g2_decap_8
XFILLER_91_666 VDD VSS sg13g2_decap_8
XFILLER_90_143 VDD VSS sg13g2_decap_4
XFILLER_44_582 VDD VSS sg13g2_decap_8
XFILLER_72_880 VDD VSS sg13g2_decap_8
XFILLER_90_176 VDD VSS sg13g2_decap_8
X_3870_ _3907_/B _3879_/D _3911_/B VDD VSS sg13g2_nand2_1
X_2821_ hold788/X _2450_/B _4840_/Q _2821_/X VDD VSS sg13g2_mux2_1
Xclkbuf_leaf_11_clk clkbuf_4_4_0_clk/X _4841_/CLK VDD VSS sg13g2_buf_8
X_2752_ _2752_/A _2752_/B _2752_/C _4953_/D VDD VSS sg13g2_nor3_1
X_4304__422 VDD VSS _4304_/RESET_B sg13g2_tiehi
X_4422_ _4422_/RESET_B VSS VDD _4422_/D _4422_/Q _4966_/CLK sg13g2_dfrbpq_1
X_2683_ _2673_/Y VDD _2693_/S VSS _2655_/A _2682_/Y sg13g2_o21ai_1
X_4353_ _4353_/RESET_B VSS VDD _4353_/D _4353_/Q _4527_/CLK sg13g2_dfrbpq_1
XFILLER_99_744 VDD VSS sg13g2_decap_8
XFILLER_113_554 VDD VSS sg13g2_decap_4
XFILLER_113_565 VDD VSS sg13g2_fill_2
XFILLER_59_608 VDD VSS sg13g2_decap_8
XFILLER_59_619 VDD VSS sg13g2_fill_2
X_4284_ _4284_/RESET_B VSS VDD _4284_/D _4284_/Q _4971_/CLK sg13g2_dfrbpq_1
X_3304_ _3394_/A _4648_/Q _3493_/A _3362_/A VDD VSS sg13g2_nor3_1
X_3235_ _3192_/A VDD _4599_/D VSS _2604_/A _3235_/A2 sg13g2_o21ai_1
XFILLER_86_438 VDD VSS sg13g2_decap_8
XFILLER_67_652 VDD VSS sg13g2_decap_8
XFILLER_104_49 VDD VSS sg13g2_decap_8
XFILLER_27_505 VDD VSS sg13g2_decap_8
XFILLER_82_611 VDD VSS sg13g2_decap_4
X_3166_ _3182_/A _3166_/B _4569_/D VDD VSS sg13g2_nor2_1
XFILLER_54_313 VDD VSS sg13g2_decap_8
XFILLER_55_847 VDD VSS sg13g2_fill_2
X_4311__415 VDD VSS _4311_/RESET_B sg13g2_tiehi
X_3097_ _4521_/Q hold948/X _3108_/S _3097_/X VDD VSS sg13g2_mux2_1
XFILLER_23_700 VDD VSS sg13g2_fill_1
XFILLER_70_817 VDD VSS sg13g2_decap_8
XFILLER_82_666 VDD VSS sg13g2_decap_8
XFILLER_63_891 VDD VSS sg13g2_fill_1
Xfanout25 _2625_/Y _3828_/A2 VDD VSS sg13g2_buf_1
Xfanout36 _2819_/B _2809_/A VDD VSS sg13g2_buf_1
Xfanout47 _3477_/C _3481_/C VDD VSS sg13g2_buf_1
XFILLER_10_416 VDD VSS sg13g2_decap_8
XFILLER_22_276 VDD VSS sg13g2_fill_1
XFILLER_50_574 VDD VSS sg13g2_decap_8
Xfanout58 _3370_/S _3369_/S VDD VSS sg13g2_buf_1
Xfanout69 _3867_/X _3952_/B1 VDD VSS sg13g2_buf_1
X_3999_ _3999_/A _4756_/Q _3999_/Y VDD VSS sg13g2_nor2b_1
XFILLER_2_615 VDD VSS sg13g2_decap_4
XFILLER_1_114 VDD VSS sg13g2_decap_8
XFILLER_104_565 VDD VSS sg13g2_fill_1
XFILLER_89_265 VDD VSS sg13g2_decap_8
XFILLER_38_21 VDD VSS sg13g2_decap_8
XFILLER_38_65 VDD VSS sg13g2_fill_1
XFILLER_38_76 VDD VSS sg13g2_fill_1
XFILLER_46_814 VDD VSS sg13g2_decap_8
XFILLER_46_825 VDD VSS sg13g2_fill_1
XFILLER_57_140 VDD VSS sg13g2_decap_8
Xhold1150 _4420_/Q VDD VSS _2993_/A0 sg13g2_dlygate4sd3_1
XFILLER_85_471 VDD VSS sg13g2_decap_8
XFILLER_45_335 VDD VSS sg13g2_fill_2
XFILLER_46_836 VDD VSS sg13g2_fill_2
XFILLER_46_869 VDD VSS sg13g2_decap_4
Xhold1161 _4532_/Q VDD VSS _3108_/A0 sg13g2_dlygate4sd3_1
Xhold1172 _2915_/X VDD VSS _4347_/D sg13g2_dlygate4sd3_1
Xhold1183 _2970_/X VDD VSS _4399_/D sg13g2_dlygate4sd3_1
Xhold1194 _2862_/X VDD VSS _4297_/D sg13g2_dlygate4sd3_1
XFILLER_73_666 VDD VSS sg13g2_fill_1
XFILLER_14_700 VDD VSS sg13g2_fill_1
XFILLER_54_42 VDD VSS sg13g2_decap_8
XFILLER_61_839 VDD VSS sg13g2_decap_8
XFILLER_72_165 VDD VSS sg13g2_fill_1
XFILLER_13_210 VDD VSS sg13g2_fill_1
XFILLER_110_70 VDD VSS sg13g2_decap_8
XFILLER_14_777 VDD VSS sg13g2_decap_8
XFILLER_6_910 VDD VSS sg13g2_decap_8
Xclkload17 clkload17/Y _4552_/CLK VDD VSS sg13g2_inv_2
Xclkload28 _4975_/CLK clkload28/X VDD VSS sg13g2_buf_8
Xclkload39 clkload39/Y _4955_/CLK VDD VSS sg13g2_inv_2
XFILLER_48_7 VDD VSS sg13g2_decap_4
XFILLER_79_83 VDD VSS sg13g2_fill_1
XFILLER_96_736 VDD VSS sg13g2_decap_4
XFILLER_110_568 VDD VSS sg13g2_fill_1
XFILLER_48_140 VDD VSS sg13g2_fill_1
XFILLER_48_151 VDD VSS sg13g2_decap_4
XFILLER_48_162 VDD VSS sg13g2_fill_2
XFILLER_64_611 VDD VSS sg13g2_decap_8
Xclkbuf_leaf_0_clk clkbuf_4_0_0_clk/X _4904_/CLK VDD VSS sg13g2_buf_8
X_3020_ _3020_/A0 _4520_/Q _3028_/S _3020_/X VDD VSS sg13g2_mux2_1
XFILLER_95_93 VDD VSS sg13g2_fill_1
XFILLER_95_82 VDD VSS sg13g2_decap_8
XFILLER_95_268 VDD VSS sg13g2_fill_2
XFILLER_37_836 VDD VSS sg13g2_decap_8
XFILLER_64_622 VDD VSS sg13g2_fill_2
XFILLER_64_644 VDD VSS sg13g2_decap_8
XFILLER_52_828 VDD VSS sg13g2_fill_2
XFILLER_63_165 VDD VSS sg13g2_decap_8
X_4971_ fanout299/X VSS VDD _4971_/D _4971_/Q _4971_/CLK sg13g2_dfrbpq_1
X_3922_ _3922_/A _3922_/B _3922_/Y VDD VSS sg13g2_nor2_1
XFILLER_20_725 VDD VSS sg13g2_decap_8
X_3853_ _3853_/Y _3853_/B1 _3852_/X _3791_/S _3419_/C VDD VSS sg13g2_a22oi_1
XFILLER_20_736 VDD VSS sg13g2_fill_1
XFILLER_20_747 VDD VSS sg13g2_decap_8
X_2804_ _2801_/B _2406_/B _2431_/A _2805_/C VDD VSS sg13g2_a21o_1
XFILLER_74_0 VDD VSS sg13g2_decap_8
X_3784_ _3786_/A VDD _3785_/B VSS _3786_/B _3786_/C sg13g2_o21ai_1
X_2735_ VSS VDD _2739_/A _2739_/C _2735_/Y _2741_/A sg13g2_a21oi_1
X_2666_ _2666_/Y _4696_/Q _2330_/A VDD VSS sg13g2_nand2b_1
X_4405_ _4405_/RESET_B VSS VDD _4405_/D _4405_/Q _4977_/CLK sg13g2_dfrbpq_1
XFILLER_99_530 VDD VSS sg13g2_decap_8
XFILLER_114_863 VDD VSS sg13g2_decap_8
Xfanout204 hold1669/X _3329_/A VDD VSS sg13g2_buf_1
X_4336_ _4336_/RESET_B VSS VDD _4336_/D _4336_/Q _4527_/CLK sg13g2_dfrbpq_1
X_2597_ _4592_/Q _4593_/Q _3222_/A _3217_/B _3224_/B VDD VSS sg13g2_or4_1
XFILLER_101_524 VDD VSS sg13g2_fill_1
Xfanout215 _4685_/Q _2678_/A VDD VSS sg13g2_buf_1
Xfanout226 hold795/X _3105_/A0 VDD VSS sg13g2_buf_1
Xfanout237 hold1222/X _3094_/A0 VDD VSS sg13g2_buf_1
XFILLER_87_747 VDD VSS sg13g2_decap_8
XFILLER_115_59 VDD VSS sg13g2_decap_8
Xfanout248 fanout256/X fanout248/X VDD VSS sg13g2_buf_1
Xfanout259 fanout260/X fanout259/X VDD VSS sg13g2_buf_1
X_4267_ _4267_/RESET_B VSS VDD _4267_/D _4267_/Q _4973_/CLK sg13g2_dfrbpq_1
XFILLER_83_920 VDD VSS sg13g2_decap_4
X_4198_ _2348_/A VDD _4198_/Y VSS _4195_/Y _4196_/Y sg13g2_o21ai_1
X_3218_ _3230_/A _3218_/B _4592_/D VDD VSS sg13g2_nor2_1
XFILLER_55_622 VDD VSS sg13g2_fill_1
X_3149_ _2503_/C VDD _3149_/Y VSS _4560_/Q _4561_/Q sg13g2_o21ai_1
XFILLER_95_791 VDD VSS sg13g2_decap_4
XFILLER_15_508 VDD VSS sg13g2_decap_8
XFILLER_42_305 VDD VSS sg13g2_decap_8
XFILLER_54_198 VDD VSS sg13g2_decap_8
XFILLER_11_714 VDD VSS sg13g2_decap_4
XFILLER_23_563 VDD VSS sg13g2_decap_8
XFILLER_51_872 VDD VSS sg13g2_decap_8
XFILLER_10_224 VDD VSS sg13g2_decap_8
XFILLER_24_78 VDD VSS sg13g2_fill_2
XFILLER_109_613 VDD VSS sg13g2_decap_8
XFILLER_108_134 VDD VSS sg13g2_decap_8
XFILLER_40_55 VDD VSS sg13g2_decap_4
XFILLER_2_401 VDD VSS sg13g2_decap_8
XFILLER_105_852 VDD VSS sg13g2_decap_8
XFILLER_105_863 VDD VSS sg13g2_fill_2
XFILLER_19_825 VDD VSS sg13g2_fill_2
XFILLER_77_257 VDD VSS sg13g2_decap_8
XFILLER_105_70 VDD VSS sg13g2_decap_8
XFILLER_1_49 VDD VSS sg13g2_decap_8
XFILLER_74_920 VDD VSS sg13g2_decap_4
XFILLER_65_63 VDD VSS sg13g2_decap_8
XFILLER_73_452 VDD VSS sg13g2_fill_2
XFILLER_60_102 VDD VSS sg13g2_decap_8
XFILLER_14_530 VDD VSS sg13g2_decap_8
XFILLER_42_850 VDD VSS sg13g2_decap_8
XFILLER_61_669 VDD VSS sg13g2_fill_1
XFILLER_81_73 VDD VSS sg13g2_decap_8
XFILLER_81_84 VDD VSS sg13g2_fill_2
XFILLER_115_605 VDD VSS sg13g2_decap_8
X_2520_ _2718_/B _2520_/A _2520_/B VDD VSS sg13g2_nand2_1
XFILLER_6_784 VDD VSS sg13g2_decap_8
X_4301__425 VDD VSS _4301_/RESET_B sg13g2_tiehi
X_2451_ _3691_/A _3636_/B _2451_/Y VDD VSS sg13g2_nor2_1
XFILLER_111_800 VDD VSS sg13g2_decap_8
XFILLER_68_202 VDD VSS sg13g2_decap_8
XFILLER_68_213 VDD VSS sg13g2_fill_2
XFILLER_69_725 VDD VSS sg13g2_decap_8
X_2382_ _2382_/A _2382_/B _2382_/C _2382_/D _2389_/B VDD VSS sg13g2_nor4_1
XFILLER_110_332 VDD VSS sg13g2_decap_8
XFILLER_68_235 VDD VSS sg13g2_decap_8
X_4121_ _4121_/B _4121_/C _4121_/A _4121_/Y VDD VSS sg13g2_nand3_1
XFILLER_96_544 VDD VSS sg13g2_decap_8
XFILLER_110_343 VDD VSS sg13g2_fill_1
XFILLER_84_717 VDD VSS sg13g2_decap_8
X_4052_ _4052_/A _4052_/B _4052_/Y VDD VSS sg13g2_nor2_1
XFILLER_110_398 VDD VSS sg13g2_decap_8
XFILLER_37_611 VDD VSS sg13g2_decap_8
XFILLER_49_493 VDD VSS sg13g2_decap_8
XFILLER_83_249 VDD VSS sg13g2_decap_8
Xinput4 rst_n input4/X VDD VSS sg13g2_buf_1
X_3003_ hold913/X _3105_/A0 _3003_/S _4430_/D VDD VSS sg13g2_mux2_1
XFILLER_36_143 VDD VSS sg13g2_decap_8
XFILLER_80_901 VDD VSS sg13g2_decap_4
XFILLER_24_305 VDD VSS sg13g2_decap_4
XFILLER_24_316 VDD VSS sg13g2_fill_2
XFILLER_37_688 VDD VSS sg13g2_decap_4
XFILLER_101_28 VDD VSS sg13g2_fill_2
XFILLER_24_338 VDD VSS sg13g2_decap_8
XFILLER_51_113 VDD VSS sg13g2_decap_8
XFILLER_52_647 VDD VSS sg13g2_decap_4
X_4954_ fanout275/X VSS VDD _4954_/D _4954_/Q _4954_/CLK sg13g2_dfrbpq_1
XFILLER_91_293 VDD VSS sg13g2_decap_8
XFILLER_33_872 VDD VSS sg13g2_fill_1
X_3905_ _4809_/Q _3905_/C _3905_/A _3905_/Y VDD VSS _3905_/D sg13g2_nand4_1
XFILLER_20_533 VDD VSS sg13g2_decap_8
X_4885_ fanout309/X VSS VDD _4885_/D _4885_/Q _4894_/CLK sg13g2_dfrbpq_1
X_3836_ _3836_/Y _3848_/A _3836_/B VDD VSS sg13g2_nand2_1
XFILLER_20_577 VDD VSS sg13g2_decap_8
X_3767_ _3767_/Y _3768_/A _3788_/B VDD VSS sg13g2_nand2_1
XFILLER_3_209 VDD VSS sg13g2_fill_1
X_2718_ _3868_/A _2718_/B _2718_/Y VDD VSS sg13g2_nor2_1
XFILLER_10_14 VDD VSS sg13g2_decap_8
X_3698_ _4748_/Q _3698_/C _3706_/A _3698_/Y VDD VSS _3698_/D sg13g2_nand4_1
X_2649_ _2696_/A _3522_/C _2499_/B VDD VSS sg13g2_nand2b_1
X_4319_ _4319_/RESET_B VSS VDD _4319_/D _4319_/Q _4817_/CLK sg13g2_dfrbpq_1
XFILLER_87_533 VDD VSS sg13g2_decap_8
XFILLER_101_365 VDD VSS sg13g2_decap_8
XFILLER_47_408 VDD VSS sg13g2_decap_4
XFILLER_19_78 VDD VSS sg13g2_decap_8
XFILLER_28_655 VDD VSS sg13g2_decap_8
XFILLER_55_441 VDD VSS sg13g2_decap_8
XFILLER_83_761 VDD VSS sg13g2_fill_1
XFILLER_16_839 VDD VSS sg13g2_decap_4
XFILLER_27_165 VDD VSS sg13g2_decap_8
XFILLER_35_11 VDD VSS sg13g2_decap_4
XFILLER_15_349 VDD VSS sg13g2_decap_8
XFILLER_43_658 VDD VSS sg13g2_decap_8
XFILLER_70_444 VDD VSS sg13g2_decap_4
XFILLER_24_861 VDD VSS sg13g2_decap_8
XFILLER_35_77 VDD VSS sg13g2_decap_8
XFILLER_70_499 VDD VSS sg13g2_decap_8
XFILLER_50_190 VDD VSS sg13g2_decap_8
XFILLER_51_43 VDD VSS sg13g2_decap_8
XFILLER_109_454 VDD VSS sg13g2_decap_8
XFILLER_4_0 VDD VSS sg13g2_decap_8
XFILLER_105_660 VDD VSS sg13g2_fill_1
XFILLER_3_765 VDD VSS sg13g2_decap_8
XFILLER_111_129 VDD VSS sg13g2_fill_1
XFILLER_78_533 VDD VSS sg13g2_decap_8
XFILLER_116_91 VDD VSS sg13g2_decap_8
XFILLER_38_408 VDD VSS sg13g2_fill_1
XFILLER_38_419 VDD VSS sg13g2_fill_2
XFILLER_66_706 VDD VSS sg13g2_decap_8
XFILLER_19_633 VDD VSS sg13g2_decap_8
XFILLER_47_920 VDD VSS sg13g2_decap_4
XFILLER_93_525 VDD VSS sg13g2_fill_2
XFILLER_18_132 VDD VSS sg13g2_fill_2
XFILLER_58_290 VDD VSS sg13g2_fill_1
XFILLER_18_154 VDD VSS sg13g2_decap_8
XFILLER_18_165 VDD VSS sg13g2_fill_2
XFILLER_73_260 VDD VSS sg13g2_decap_4
XFILLER_74_794 VDD VSS sg13g2_decap_8
XFILLER_80_208 VDD VSS sg13g2_decap_8
XFILLER_22_809 VDD VSS sg13g2_fill_1
XFILLER_33_124 VDD VSS sg13g2_fill_2
XFILLER_33_135 VDD VSS sg13g2_decap_8
XFILLER_34_658 VDD VSS sg13g2_fill_1
XFILLER_21_308 VDD VSS sg13g2_decap_8
XFILLER_61_455 VDD VSS sg13g2_decap_8
XFILLER_61_466 VDD VSS sg13g2_fill_2
XFILLER_61_477 VDD VSS sg13g2_decap_8
XFILLER_30_864 VDD VSS sg13g2_decap_8
XFILLER_30_875 VDD VSS sg13g2_fill_1
X_4670_ fanout269/X VSS VDD _4670_/D _4670_/Q _4745_/CLK sg13g2_dfrbpq_1
X_3621_ _3621_/A0 _4628_/Q _3653_/S _3621_/X VDD VSS sg13g2_mux2_1
X_3552_ _4714_/Q _3552_/A1 _3552_/S _3552_/X VDD VSS sg13g2_mux2_1
XFILLER_6_570 VDD VSS sg13g2_fill_1
X_2503_ _4560_/Q _4561_/Q _2503_/C _3152_/A _3154_/B VDD VSS sg13g2_or4_1
X_3483_ _3483_/B _3483_/C _3483_/A _3483_/Y VDD VSS sg13g2_nand3_1
X_2434_ _2434_/A _2805_/B _2806_/B VDD VSS sg13g2_nor2_1
XFILLER_37_0 VDD VSS sg13g2_decap_8
X_2365_ _2365_/Y _4659_/Q _4651_/Q VDD VSS sg13g2_nand2_1
XFILLER_110_140 VDD VSS sg13g2_decap_4
XFILLER_111_652 VDD VSS sg13g2_fill_1
XFILLER_69_577 VDD VSS sg13g2_decap_8
X_4104_ _4196_/B1 VDD _4104_/Y VSS _4196_/A1 _4445_/Q sg13g2_o21ai_1
XFILLER_97_864 VDD VSS sg13g2_decap_8
XFILLER_96_363 VDD VSS sg13g2_decap_8
XFILLER_111_696 VDD VSS sg13g2_decap_4
XFILLER_57_739 VDD VSS sg13g2_decap_8
XFILLER_84_547 VDD VSS sg13g2_decap_8
X_2296_ VDD _3826_/A _3751_/B VSS sg13g2_inv_1
XFILLER_72_709 VDD VSS sg13g2_decap_8
X_4035_ _4035_/Y _4035_/B _4227_/B1 VDD VSS sg13g2_nand2b_1
XFILLER_112_38 VDD VSS sg13g2_fill_2
XFILLER_112_49 VDD VSS sg13g2_decap_8
XFILLER_25_603 VDD VSS sg13g2_fill_1
XFILLER_24_124 VDD VSS sg13g2_decap_8
XFILLER_92_580 VDD VSS sg13g2_decap_8
XFILLER_80_786 VDD VSS sg13g2_fill_2
X_4937_ fanout334/X VSS VDD _4937_/D _4937_/Q _4941_/CLK sg13g2_dfrbpq_1
XFILLER_21_864 VDD VSS sg13g2_decap_8
X_4868_ fanout326/X VSS VDD _4868_/D _4868_/Q _4868_/CLK sg13g2_dfrbpq_1
XFILLER_20_363 VDD VSS sg13g2_decap_4
X_3819_ _3819_/Y _3807_/Y _3818_/Y _3837_/A2 _3411_/B VDD VSS sg13g2_a22oi_1
X_4799_ fanout315/X VSS VDD _4799_/D _4799_/Q _4931_/CLK sg13g2_dfrbpq_1
XFILLER_106_413 VDD VSS sg13g2_decap_8
XFILLER_115_7 VDD VSS sg13g2_decap_8
XFILLER_0_746 VDD VSS sg13g2_decap_8
XFILLER_88_842 VDD VSS sg13g2_decap_8
XFILLER_88_831 VDD VSS sg13g2_fill_1
XFILLER_75_503 VDD VSS sg13g2_decap_8
XFILLER_88_886 VDD VSS sg13g2_fill_1
XFILLER_46_21 VDD VSS sg13g2_decap_8
XFILLER_90_506 VDD VSS sg13g2_fill_1
XFILLER_44_923 VDD VSS sg13g2_fill_2
XFILLER_55_260 VDD VSS sg13g2_decap_8
XFILLER_56_761 VDD VSS sg13g2_decap_8
XFILLER_28_496 VDD VSS sg13g2_decap_8
XFILLER_70_263 VDD VSS sg13g2_decap_8
XFILLER_71_786 VDD VSS sg13g2_decap_8
XFILLER_62_42 VDD VSS sg13g2_decap_4
XFILLER_7_356 VDD VSS sg13g2_decap_8
XFILLER_109_273 VDD VSS sg13g2_decap_8
XFILLER_112_416 VDD VSS sg13g2_fill_2
XFILLER_11_90 VDD VSS sg13g2_decap_8
XFILLER_105_490 VDD VSS sg13g2_decap_8
XFILLER_112_427 VDD VSS sg13g2_decap_8
XFILLER_30_7 VDD VSS sg13g2_decap_8
XFILLER_79_875 VDD VSS sg13g2_fill_2
XFILLER_38_216 VDD VSS sg13g2_decap_8
XFILLER_78_396 VDD VSS sg13g2_fill_1
XFILLER_93_311 VDD VSS sg13g2_decap_8
XFILLER_94_856 VDD VSS sg13g2_decap_8
XFILLER_19_474 VDD VSS sg13g2_decap_8
XFILLER_47_761 VDD VSS sg13g2_decap_8
XFILLER_53_208 VDD VSS sg13g2_fill_2
XFILLER_81_528 VDD VSS sg13g2_fill_1
XFILLER_34_477 VDD VSS sg13g2_fill_2
XFILLER_61_241 VDD VSS sg13g2_decap_8
XFILLER_62_786 VDD VSS sg13g2_decap_8
X_2983_ _2983_/A _3009_/B _2983_/Y VDD VSS sg13g2_nor2_1
X_4722_ fanout332/X VSS VDD _4722_/D _4722_/Q _4933_/CLK sg13g2_dfrbpq_1
X_4653_ fanout263/X VSS VDD _4653_/D _4653_/Q _4658_/CLK sg13g2_dfrbpq_1
Xhold802 _4463_/Q VDD VSS hold802/X sg13g2_dlygate4sd3_1
X_4584_ fanout288/X VSS VDD _4584_/D _4584_/Q _4601_/CLK sg13g2_dfrbpq_1
X_3604_ _3604_/B _3604_/A _3604_/X VDD VSS sg13g2_xor2_1
XFILLER_115_232 VDD VSS sg13g2_fill_2
XFILLER_116_733 VDD VSS sg13g2_decap_8
Xhold846 _3025_/X VDD VSS _4451_/D sg13g2_dlygate4sd3_1
Xhold835 _2933_/X VDD VSS _4363_/D sg13g2_dlygate4sd3_1
Xhold824 _4412_/Q VDD VSS hold824/X sg13g2_dlygate4sd3_1
Xhold813 _3446_/Y VDD VSS _4660_/D sg13g2_dlygate4sd3_1
X_3535_ _4697_/Q _3535_/A1 _3552_/S _3535_/X VDD VSS sg13g2_mux2_1
XFILLER_104_917 VDD VSS sg13g2_decap_8
XFILLER_107_27 VDD VSS sg13g2_fill_1
Xhold879 _2917_/X VDD VSS _4349_/D sg13g2_dlygate4sd3_1
Xhold868 _2955_/X VDD VSS _4385_/D sg13g2_dlygate4sd3_1
Xhold857 _4798_/Q VDD VSS hold857/X sg13g2_dlygate4sd3_1
X_3466_ _3465_/Y VDD _4670_/D VSS _2284_/Y _3481_/C sg13g2_o21ai_1
X_2417_ _2434_/A _2429_/B _2417_/C _2418_/B VDD VSS sg13g2_nor3_1
XFILLER_69_341 VDD VSS sg13g2_decap_8
X_3397_ _4782_/Q _4781_/Q _4784_/Q _3398_/D VDD VSS _4779_/Q sg13g2_nand4_1
XFILLER_29_205 VDD VSS sg13g2_decap_8
XFILLER_57_536 VDD VSS sg13g2_decap_8
Xhold1502 _2812_/X VDD VSS _2813_/B sg13g2_dlygate4sd3_1
Xhold1513 _4571_/Q VDD VSS _3169_/A sg13g2_dlygate4sd3_1
Xhold1524 _4731_/Q VDD VSS _3619_/A0 sg13g2_dlygate4sd3_1
Xhold1535 _2443_/Y VDD VSS _4913_/D sg13g2_dlygate4sd3_1
X_2348_ VDD _2348_/Y _2348_/A VSS sg13g2_inv_1
XFILLER_85_834 VDD VSS sg13g2_fill_2
Xhold1546 _4717_/Q VDD VSS _3563_/A sg13g2_dlygate4sd3_1
Xhold1557 _3297_/X VDD VSS _4626_/D sg13g2_dlygate4sd3_1
Xhold1568 _4727_/Q VDD VSS _3607_/A sg13g2_dlygate4sd3_1
X_2279_ VDD _2279_/Y _4676_/Q VSS sg13g2_inv_1
XFILLER_85_878 VDD VSS sg13g2_decap_8
XFILLER_25_400 VDD VSS sg13g2_decap_8
XFILLER_38_772 VDD VSS sg13g2_decap_8
XFILLER_44_208 VDD VSS sg13g2_decap_8
XFILLER_84_388 VDD VSS sg13g2_decap_8
Xhold1579 _4770_/Q VDD VSS _3844_/A sg13g2_dlygate4sd3_1
X_4018_ _4017_/Y VDD _4018_/Y VSS _4015_/Y _4016_/Y sg13g2_o21ai_1
XFILLER_65_580 VDD VSS sg13g2_fill_1
XFILLER_13_606 VDD VSS sg13g2_decap_8
XFILLER_16_46 VDD VSS sg13g2_fill_1
XFILLER_53_775 VDD VSS sg13g2_decap_4
XFILLER_25_477 VDD VSS sg13g2_fill_1
XFILLER_25_488 VDD VSS sg13g2_fill_1
XFILLER_40_469 VDD VSS sg13g2_decap_8
XFILLER_32_56 VDD VSS sg13g2_decap_8
XFILLER_20_171 VDD VSS sg13g2_decap_4
XFILLER_5_816 VDD VSS sg13g2_decap_8
XFILLER_106_210 VDD VSS sg13g2_decap_8
XFILLER_0_543 VDD VSS sg13g2_decap_8
XFILLER_110_909 VDD VSS sg13g2_decap_8
XFILLER_76_801 VDD VSS sg13g2_decap_8
XFILLER_48_503 VDD VSS sg13g2_decap_8
XFILLER_75_300 VDD VSS sg13g2_decap_8
XFILLER_76_845 VDD VSS sg13g2_decap_8
XFILLER_88_683 VDD VSS sg13g2_decap_8
XFILLER_102_493 VDD VSS sg13g2_decap_8
XFILLER_29_750 VDD VSS sg13g2_decap_8
XFILLER_57_75 VDD VSS sg13g2_decap_8
XFILLER_17_923 VDD VSS sg13g2_fill_2
XFILLER_90_314 VDD VSS sg13g2_decap_8
XFILLER_28_293 VDD VSS sg13g2_decap_8
XFILLER_43_252 VDD VSS sg13g2_decap_4
XFILLER_73_63 VDD VSS sg13g2_decap_8
XFILLER_44_797 VDD VSS sg13g2_decap_8
XFILLER_12_661 VDD VSS sg13g2_decap_8
XFILLER_78_7 VDD VSS sg13g2_decap_8
XFILLER_8_654 VDD VSS sg13g2_decap_4
XFILLER_11_193 VDD VSS sg13g2_fill_2
XFILLER_7_142 VDD VSS sg13g2_decap_8
X_3320_ _3313_/Y VDD _3327_/A VSS _3412_/B _3319_/Y sg13g2_o21ai_1
XFILLER_3_381 VDD VSS sg13g2_fill_2
XFILLER_4_893 VDD VSS sg13g2_decap_8
XFILLER_98_447 VDD VSS sg13g2_decap_8
X_3251_ _3251_/Y _3251_/A _3251_/B VDD VSS sg13g2_xnor2_1
X_3182_ _3182_/A _3182_/B _4576_/D VDD VSS sg13g2_nor2_1
XFILLER_39_558 VDD VSS sg13g2_fill_1
XFILLER_19_271 VDD VSS sg13g2_decap_4
XFILLER_35_720 VDD VSS sg13g2_decap_8
XFILLER_54_539 VDD VSS sg13g2_decap_8
XFILLER_81_336 VDD VSS sg13g2_decap_8
XFILLER_93_185 VDD VSS sg13g2_decap_8
XFILLER_34_241 VDD VSS sg13g2_decap_8
XFILLER_35_764 VDD VSS sg13g2_fill_1
XFILLER_50_701 VDD VSS sg13g2_decap_8
XFILLER_22_414 VDD VSS sg13g2_decap_8
XFILLER_34_285 VDD VSS sg13g2_decap_8
XFILLER_62_583 VDD VSS sg13g2_fill_1
XFILLER_22_447 VDD VSS sg13g2_decap_8
XFILLER_50_745 VDD VSS sg13g2_fill_1
XFILLER_50_789 VDD VSS sg13g2_decap_4
X_2966_ hold870/X _3095_/A0 _2975_/S _2966_/X VDD VSS sg13g2_mux2_1
X_4705_ fanout302/X VSS VDD _4705_/D _4705_/Q _4884_/CLK sg13g2_dfrbpq_1
X_2897_ _2897_/A0 _3105_/A0 _2900_/S _4330_/D VDD VSS sg13g2_mux2_1
X_4636_ fanout251/X VSS VDD _4636_/D _4636_/Q clkload3/A sg13g2_dfrbpq_1
XFILLER_8_91 VDD VSS sg13g2_decap_8
Xhold610 _3998_/Y VDD VSS _4836_/D sg13g2_dlygate4sd3_1
Xhold621 _3994_/Y VDD VSS _4835_/D sg13g2_dlygate4sd3_1
XFILLER_104_703 VDD VSS sg13g2_decap_8
Xhold632 _4633_/Q VDD VSS _3348_/A sg13g2_dlygate4sd3_1
Xhold654 _4229_/Y VDD VSS _4976_/D sg13g2_dlygate4sd3_1
Xhold643 _3143_/Y VDD VSS _4559_/D sg13g2_dlygate4sd3_1
X_4567_ fanout329/X VSS VDD _4567_/D _4567_/Q _4580_/CLK sg13g2_dfrbpq_1
Xhold687 _4886_/Q VDD VSS _2566_/B sg13g2_dlygate4sd3_1
Xhold676 _2779_/Y VDD VSS _2782_/A sg13g2_dlygate4sd3_1
Xhold665 _4045_/Y VDD VSS _4958_/D sg13g2_dlygate4sd3_1
X_4498_ fanout302/X VSS VDD _4498_/D _4498_/Q _4877_/CLK sg13g2_dfrbpq_1
X_3518_ _3519_/B _3518_/B _4688_/D VDD VSS sg13g2_and2_1
XFILLER_89_425 VDD VSS sg13g2_decap_8
XFILLER_103_246 VDD VSS sg13g2_decap_8
XFILLER_77_609 VDD VSS sg13g2_decap_8
Xhold698 _3982_/Y VDD VSS _4832_/D sg13g2_dlygate4sd3_1
X_3449_ _3453_/B _3453_/C _3449_/A _3449_/Y VDD VSS sg13g2_nand3_1
XFILLER_69_193 VDD VSS sg13g2_decap_8
Xhold1310 _4705_/Q VDD VSS _3543_/A0 sg13g2_dlygate4sd3_1
Xhold1321 _4767_/Q VDD VSS _3800_/A sg13g2_dlygate4sd3_1
Xhold1332 _4738_/Q VDD VSS hold1332/X sg13g2_dlygate4sd3_1
Xhold1343 _3955_/Y VDD VSS _3956_/B sg13g2_dlygate4sd3_1
XFILLER_85_642 VDD VSS sg13g2_decap_8
XFILLER_17_219 VDD VSS sg13g2_decap_8
XFILLER_45_528 VDD VSS sg13g2_decap_8
XFILLER_57_355 VDD VSS sg13g2_decap_4
Xhold1354 _4655_/Q VDD VSS _3433_/A sg13g2_dlygate4sd3_1
Xhold1365 _3496_/Y VDD VSS _4683_/D sg13g2_dlygate4sd3_1
Xhold1376 _4669_/Q VDD VSS _3461_/A sg13g2_dlygate4sd3_1
XFILLER_27_56 VDD VSS sg13g2_decap_8
Xhold1387 _3121_/X VDD VSS _4545_/D sg13g2_dlygate4sd3_1
Xhold1398 _3361_/X VDD VSS _3362_/B sg13g2_dlygate4sd3_1
XFILLER_13_414 VDD VSS sg13g2_decap_8
XFILLER_25_285 VDD VSS sg13g2_decap_4
XFILLER_81_870 VDD VSS sg13g2_decap_8
XFILLER_40_222 VDD VSS sg13g2_decap_4
XFILLER_80_391 VDD VSS sg13g2_decap_8
XFILLER_9_429 VDD VSS sg13g2_decap_8
XFILLER_104_0 VDD VSS sg13g2_decap_8
XFILLER_5_679 VDD VSS sg13g2_decap_8
XFILLER_107_585 VDD VSS sg13g2_decap_8
XFILLER_4_49 VDD VSS sg13g2_decap_8
XFILLER_1_852 VDD VSS sg13g2_decap_8
XFILLER_49_801 VDD VSS sg13g2_decap_8
XFILLER_68_609 VDD VSS sg13g2_decap_8
XFILLER_0_340 VDD VSS sg13g2_decap_8
XFILLER_48_300 VDD VSS sg13g2_decap_8
XFILLER_67_119 VDD VSS sg13g2_fill_2
XFILLER_68_74 VDD VSS sg13g2_decap_8
XFILLER_95_439 VDD VSS sg13g2_fill_1
XFILLER_95_428 VDD VSS sg13g2_decap_8
XFILLER_49_878 VDD VSS sg13g2_decap_8
XFILLER_75_163 VDD VSS sg13g2_decap_8
XFILLER_76_686 VDD VSS sg13g2_decap_8
XFILLER_48_399 VDD VSS sg13g2_decap_8
XFILLER_63_336 VDD VSS sg13g2_decap_8
XFILLER_64_859 VDD VSS sg13g2_decap_8
XFILLER_91_645 VDD VSS sg13g2_decap_8
XFILLER_17_753 VDD VSS sg13g2_fill_2
XFILLER_63_369 VDD VSS sg13g2_fill_1
XFILLER_16_285 VDD VSS sg13g2_decap_8
XFILLER_31_233 VDD VSS sg13g2_decap_8
XFILLER_31_277 VDD VSS sg13g2_decap_8
X_2820_ _4840_/Q hold788/X _4942_/D _2820_/X VDD VSS sg13g2_a21o_1
XFILLER_12_491 VDD VSS sg13g2_decap_4
X_2751_ _2751_/A _2751_/B _2752_/C VDD VSS sg13g2_and2_1
XFILLER_8_440 VDD VSS sg13g2_decap_8
X_2682_ _2682_/Y _4687_/Q _2682_/B VDD VSS sg13g2_xnor2_1
X_4421_ _4421_/RESET_B VSS VDD _4421_/D _4421_/Q _4824_/CLK sg13g2_dfrbpq_1
XFILLER_8_495 VDD VSS sg13g2_fill_1
XFILLER_8_484 VDD VSS sg13g2_decap_8
XFILLER_99_712 VDD VSS sg13g2_decap_4
XFILLER_113_533 VDD VSS sg13g2_decap_8
X_4352_ _4352_/RESET_B VSS VDD _4352_/D _4352_/Q _4958_/CLK sg13g2_dfrbpq_1
XFILLER_101_706 VDD VSS sg13g2_decap_8
XFILLER_4_690 VDD VSS sg13g2_decap_8
X_4283_ _4283_/RESET_B VSS VDD _4283_/D _4283_/Q _4397_/CLK sg13g2_dfrbpq_1
X_3303_ _3439_/A _3625_/A1 _3368_/S _4632_/D VDD VSS sg13g2_mux2_1
XFILLER_87_907 VDD VSS sg13g2_decap_8
X_3234_ _3234_/B _3234_/A _3234_/X VDD VSS sg13g2_xor2_1
XFILLER_98_277 VDD VSS sg13g2_fill_2
XFILLER_98_266 VDD VSS sg13g2_decap_8
XFILLER_39_355 VDD VSS sg13g2_decap_8
XFILLER_39_366 VDD VSS sg13g2_fill_2
XFILLER_66_163 VDD VSS sg13g2_decap_8
X_3165_ _3167_/B _3164_/Y _3165_/Y VDD VSS sg13g2_nor2b_1
XFILLER_55_837 VDD VSS sg13g2_decap_4
XFILLER_81_111 VDD VSS sg13g2_decap_8
XFILLER_82_645 VDD VSS sg13g2_decap_8
X_3096_ _3096_/A0 _3121_/A1 _3104_/S _4520_/D VDD VSS sg13g2_mux2_1
XFILLER_94_483 VDD VSS sg13g2_fill_1
XFILLER_42_509 VDD VSS sg13g2_decap_8
XFILLER_54_369 VDD VSS sg13g2_decap_8
XFILLER_63_870 VDD VSS sg13g2_decap_8
XFILLER_35_594 VDD VSS sg13g2_fill_1
Xfanout26 _3805_/X _3848_/A VDD VSS sg13g2_buf_1
Xfanout37 _3985_/B _4003_/B VDD VSS sg13g2_buf_1
XFILLER_13_14 VDD VSS sg13g2_decap_8
XFILLER_22_255 VDD VSS sg13g2_decap_8
XFILLER_50_553 VDD VSS sg13g2_decap_8
Xfanout48 _3483_/C _3477_/C VDD VSS sg13g2_buf_1
Xfanout59 _3370_/S _3368_/S VDD VSS sg13g2_buf_1
X_3998_ _3997_/Y VDD _3998_/Y VSS _4003_/B _3996_/Y sg13g2_o21ai_1
XFILLER_13_36 VDD VSS sg13g2_decap_8
X_2949_ _2949_/A0 _3104_/A0 _2949_/S _4379_/D VDD VSS sg13g2_mux2_1
XFILLER_108_327 VDD VSS sg13g2_decap_8
X_4619_ fanout281/X VSS VDD _4619_/D _4619_/Q _4619_/CLK sg13g2_dfrbpq_1
XFILLER_89_211 VDD VSS sg13g2_decap_8
XFILLER_89_244 VDD VSS sg13g2_decap_8
XFILLER_73_612 VDD VSS sg13g2_decap_8
Xhold1140 _4406_/Q VDD VSS _2977_/A0 sg13g2_dlygate4sd3_1
Xhold1151 _4329_/Q VDD VSS _2896_/A0 sg13g2_dlygate4sd3_1
XFILLER_85_450 VDD VSS sg13g2_decap_8
XFILLER_45_325 VDD VSS sg13g2_decap_4
XFILLER_46_848 VDD VSS sg13g2_decap_8
Xhold1162 _4753_/Q VDD VSS _2343_/A sg13g2_dlygate4sd3_1
Xhold1173 _4304_/Q VDD VSS _2869_/A0 sg13g2_dlygate4sd3_1
Xhold1184 _4362_/Q VDD VSS _2932_/A0 sg13g2_dlygate4sd3_1
XFILLER_85_494 VDD VSS sg13g2_fill_1
XFILLER_54_21 VDD VSS sg13g2_decap_8
XFILLER_72_144 VDD VSS sg13g2_decap_8
Xhold1195 _4277_/Q VDD VSS _2840_/A0 sg13g2_dlygate4sd3_1
XFILLER_54_54 VDD VSS sg13g2_fill_2
XFILLER_60_328 VDD VSS sg13g2_decap_4
XFILLER_13_233 VDD VSS sg13g2_decap_8
XFILLER_14_756 VDD VSS sg13g2_decap_8
XFILLER_13_244 VDD VSS sg13g2_fill_2
XFILLER_41_575 VDD VSS sg13g2_decap_8
XFILLER_41_597 VDD VSS sg13g2_fill_2
Xclkload18 VDD clkload18/Y _4964_/CLK VSS sg13g2_inv_1
Xclkload29 clkload29/Y _4869_/CLK VDD VSS sg13g2_inv_2
XFILLER_108_850 VDD VSS sg13g2_decap_8
XFILLER_5_498 VDD VSS sg13g2_decap_8
XFILLER_79_62 VDD VSS sg13g2_decap_8
XFILLER_69_918 VDD VSS sg13g2_decap_8
XFILLER_96_704 VDD VSS sg13g2_decap_8
XFILLER_110_503 VDD VSS sg13g2_fill_1
XFILLER_1_671 VDD VSS sg13g2_decap_8
XFILLER_95_247 VDD VSS sg13g2_decap_8
XFILLER_37_815 VDD VSS sg13g2_decap_8
XFILLER_76_461 VDD VSS sg13g2_decap_8
XFILLER_48_185 VDD VSS sg13g2_decap_8
XFILLER_76_472 VDD VSS sg13g2_fill_2
XFILLER_52_818 VDD VSS sg13g2_fill_2
XFILLER_91_464 VDD VSS sg13g2_decap_8
X_4970_ fanout321/X VSS VDD _4970_/D _4970_/Q _4979_/CLK sg13g2_dfrbpq_1
XFILLER_91_497 VDD VSS sg13g2_decap_8
XFILLER_44_391 VDD VSS sg13g2_decap_8
X_3921_ _3930_/A _3936_/B _3922_/B VDD VSS sg13g2_nor2_1
XFILLER_20_704 VDD VSS sg13g2_decap_8
X_3852_ _3852_/A _3852_/B _3852_/X VDD VSS sg13g2_and2_1
X_2803_ VSS VDD _2406_/B _2801_/B _2803_/Y _2802_/Y sg13g2_a21oi_1
X_3783_ _2757_/Y VDD _3785_/A VSS _3786_/B _3782_/Y sg13g2_o21ai_1
XFILLER_67_0 VDD VSS sg13g2_decap_8
X_2734_ _2752_/A _2739_/C _2734_/C _4947_/D VDD VSS sg13g2_nor3_1
XFILLER_9_782 VDD VSS sg13g2_decap_4
X_2665_ _2677_/A _4692_/Q _4693_/Q _4694_/Q _4695_/Q _2678_/A _2665_/X VDD VSS sg13g2_mux4_1
XFILLER_105_319 VDD VSS sg13g2_decap_8
X_4404_ _4404_/RESET_B VSS VDD _4404_/D _4404_/Q _4552_/CLK sg13g2_dfrbpq_1
X_2596_ _3217_/A _2596_/B _3217_/B _3222_/B VDD VSS sg13g2_nor3_1
Xfanout205 hold1668/X _3792_/B VDD VSS sg13g2_buf_1
X_4335_ _4335_/RESET_B VSS VDD _4335_/D _4335_/Q _4961_/CLK sg13g2_dfrbpq_1
XFILLER_101_514 VDD VSS sg13g2_decap_4
Xfanout216 _2330_/A _2677_/A VDD VSS sg13g2_buf_1
Xfanout227 hold810/X _3104_/A0 VDD VSS sg13g2_buf_1
Xfanout238 hold792/X _3017_/A1 VDD VSS sg13g2_buf_1
XFILLER_99_586 VDD VSS sg13g2_decap_8
XFILLER_87_726 VDD VSS sg13g2_decap_8
XFILLER_86_203 VDD VSS sg13g2_fill_2
XFILLER_115_38 VDD VSS sg13g2_decap_8
Xfanout249 fanout256/X fanout249/X VDD VSS sg13g2_buf_1
X_4266_ _4266_/RESET_B VSS VDD _4266_/D _4266_/Q clkload5/A sg13g2_dfrbpq_1
XFILLER_86_225 VDD VSS sg13g2_decap_8
X_4197_ _4379_/Q _4404_/Q _4197_/S _4197_/X VDD VSS sg13g2_mux2_1
X_3217_ _3217_/B _3217_/A _3217_/X VDD VSS sg13g2_xor2_1
XFILLER_95_770 VDD VSS sg13g2_decap_8
XFILLER_27_314 VDD VSS sg13g2_fill_1
XFILLER_28_859 VDD VSS sg13g2_decap_8
XFILLER_67_483 VDD VSS sg13g2_decap_8
X_3148_ _3145_/B VDD _3148_/Y VSS _3144_/A _3147_/X sg13g2_o21ai_1
XFILLER_82_431 VDD VSS sg13g2_decap_8
XFILLER_54_177 VDD VSS sg13g2_decap_8
X_3079_ _4201_/B _3079_/A1 _3079_/S _4503_/D VDD VSS sg13g2_mux2_1
XFILLER_51_851 VDD VSS sg13g2_decap_8
XFILLER_24_57 VDD VSS sg13g2_decap_8
XFILLER_10_214 VDD VSS sg13g2_fill_1
XFILLER_11_759 VDD VSS sg13g2_decap_8
XFILLER_7_708 VDD VSS sg13g2_decap_8
XFILLER_108_102 VDD VSS sg13g2_fill_2
XFILLER_108_113 VDD VSS sg13g2_decap_8
XFILLER_2_479 VDD VSS sg13g2_decap_8
XFILLER_77_236 VDD VSS sg13g2_decap_8
XFILLER_78_748 VDD VSS sg13g2_decap_8
XFILLER_1_28 VDD VSS sg13g2_decap_8
XFILLER_100_580 VDD VSS sg13g2_fill_2
XFILLER_65_42 VDD VSS sg13g2_decap_8
XFILLER_45_144 VDD VSS sg13g2_decap_8
XFILLER_73_442 VDD VSS sg13g2_fill_1
XFILLER_27_870 VDD VSS sg13g2_decap_4
XFILLER_45_155 VDD VSS sg13g2_fill_1
XFILLER_46_678 VDD VSS sg13g2_fill_1
XFILLER_61_637 VDD VSS sg13g2_fill_1
XFILLER_33_339 VDD VSS sg13g2_decap_8
XFILLER_60_158 VDD VSS sg13g2_decap_8
XFILLER_81_52 VDD VSS sg13g2_decap_8
XFILLER_60_7 VDD VSS sg13g2_decap_8
XFILLER_6_763 VDD VSS sg13g2_decap_8
X_2450_ _3636_/B _2450_/B _4004_/A VDD VSS sg13g2_nand2b_1
XFILLER_5_295 VDD VSS sg13g2_decap_8
X_2381_ _2362_/Y VDD _2382_/D VSS _4680_/Q _4672_/Q sg13g2_o21ai_1
XFILLER_110_311 VDD VSS sg13g2_decap_8
X_4120_ _4119_/Y VDD _4121_/C VSS _4116_/Y _4117_/Y sg13g2_o21ai_1
XFILLER_111_867 VDD VSS sg13g2_decap_4
XFILLER_1_490 VDD VSS sg13g2_fill_2
X_4051_ hold973/X hold934/X _4052_/A _4051_/X VDD VSS sg13g2_mux2_1
XFILLER_110_377 VDD VSS sg13g2_decap_8
XFILLER_49_472 VDD VSS sg13g2_decap_4
XFILLER_83_217 VDD VSS sg13g2_decap_4
Xinput5 slot_sel[0] input5/X VDD VSS sg13g2_buf_1
X_3002_ _3002_/A0 _3104_/A0 _3002_/S _4429_/D VDD VSS sg13g2_mux2_1
XFILLER_25_807 VDD VSS sg13g2_decap_8
XFILLER_37_667 VDD VSS sg13g2_decap_8
XFILLER_76_291 VDD VSS sg13g2_decap_8
X_4953_ fanout275/X VSS VDD _4953_/D _4953_/Q _4954_/CLK sg13g2_dfrbpq_1
XFILLER_32_350 VDD VSS sg13g2_decap_4
X_3904_ _3904_/Y _3905_/C _3904_/B VDD VSS sg13g2_nand2_1
XFILLER_20_512 VDD VSS sg13g2_decap_8
XFILLER_32_383 VDD VSS sg13g2_decap_8
X_4884_ fanout303/X VSS VDD _4884_/D _4884_/Q _4884_/CLK sg13g2_dfrbpq_1
X_3835_ _3836_/B _3835_/A _3835_/B VDD VSS sg13g2_xnor2_1
X_3766_ _3763_/Y VDD _3766_/Y VSS _3766_/A1 _3765_/Y sg13g2_o21ai_1
X_2717_ VSS VDD _2717_/X _3307_/B _3394_/A sg13g2_or2_1
X_3697_ _3697_/Y _3697_/A _3697_/B VDD VSS sg13g2_nand2_1
X_2648_ _3574_/A _2692_/A _2648_/C _2703_/B _2648_/Y VDD VSS sg13g2_nor4_1
X_2579_ VSS VDD _4891_/Q _2583_/D _2579_/Y _2583_/B sg13g2_a21oi_1
XFILLER_102_856 VDD VSS sg13g2_decap_8
X_4318_ _4318_/RESET_B VSS VDD _4318_/D _4318_/Q clkload7/A sg13g2_dfrbpq_1
XFILLER_101_344 VDD VSS sg13g2_decap_8
XFILLER_19_35 VDD VSS sg13g2_fill_1
X_4249_ _4251_/S _4435_/Q _4249_/Y VDD VSS sg13g2_nor2_1
XFILLER_87_556 VDD VSS sg13g2_fill_1
XFILLER_28_634 VDD VSS sg13g2_decap_8
XFILLER_56_921 VDD VSS sg13g2_decap_4
XFILLER_55_420 VDD VSS sg13g2_decap_8
XFILLER_16_818 VDD VSS sg13g2_decap_8
XFILLER_71_924 VDD VSS sg13g2_fill_2
XFILLER_27_188 VDD VSS sg13g2_fill_1
XFILLER_35_56 VDD VSS sg13g2_decap_8
XFILLER_42_114 VDD VSS sg13g2_decap_8
XFILLER_43_637 VDD VSS sg13g2_decap_8
XFILLER_55_497 VDD VSS sg13g2_decap_8
XFILLER_82_283 VDD VSS sg13g2_decap_8
XFILLER_30_309 VDD VSS sg13g2_fill_1
XFILLER_70_478 VDD VSS sg13g2_decap_8
XFILLER_23_372 VDD VSS sg13g2_fill_1
XFILLER_23_394 VDD VSS sg13g2_decap_8
XFILLER_109_422 VDD VSS sg13g2_decap_8
XFILLER_7_516 VDD VSS sg13g2_decap_8
XFILLER_7_549 VDD VSS sg13g2_decap_8
XFILLER_51_99 VDD VSS sg13g2_decap_8
XFILLER_3_744 VDD VSS sg13g2_decap_8
XFILLER_78_512 VDD VSS sg13g2_decap_8
XFILLER_116_70 VDD VSS sg13g2_decap_8
XFILLER_78_589 VDD VSS sg13g2_decap_8
XFILLER_46_442 VDD VSS sg13g2_decap_8
XFILLER_34_626 VDD VSS sg13g2_decap_4
XFILLER_46_475 VDD VSS sg13g2_decap_8
XFILLER_46_486 VDD VSS sg13g2_fill_2
XFILLER_33_103 VDD VSS sg13g2_decap_8
XFILLER_61_434 VDD VSS sg13g2_decap_8
XFILLER_73_283 VDD VSS sg13g2_decap_8
XFILLER_15_873 VDD VSS sg13g2_decap_8
XFILLER_92_84 VDD VSS sg13g2_decap_4
XFILLER_14_361 VDD VSS sg13g2_decap_8
XFILLER_42_681 VDD VSS sg13g2_decap_8
XFILLER_30_843 VDD VSS sg13g2_decap_8
X_3620_ _3620_/A0 hold954/X _3653_/S _4732_/D VDD VSS sg13g2_mux2_1
XFILLER_116_915 VDD VSS sg13g2_decap_8
X_3551_ _4713_/Q hold967/X _3551_/S _3551_/X VDD VSS sg13g2_mux2_1
X_2502_ _3147_/A _4561_/Q _2503_/C _3152_/B VDD VSS sg13g2_nor3_1
XFILLER_115_436 VDD VSS sg13g2_fill_2
XFILLER_115_447 VDD VSS sg13g2_decap_8
X_3482_ _3481_/Y VDD _4678_/D VSS _2283_/Y _3477_/C sg13g2_o21ai_1
X_2433_ _2433_/A _4913_/Q _2433_/C _2805_/B _2433_/Y VDD VSS sg13g2_nor4_1
XFILLER_97_810 VDD VSS sg13g2_fill_2
XFILLER_102_119 VDD VSS sg13g2_decap_8
X_2364_ _2382_/A _4677_/Q _4669_/Q VDD VSS sg13g2_xnor2_1
XFILLER_57_718 VDD VSS sg13g2_decap_8
XFILLER_69_556 VDD VSS sg13g2_decap_8
X_4103_ _4197_/S _4420_/Q _4103_/Y VDD VSS sg13g2_nor2_1
XFILLER_97_887 VDD VSS sg13g2_fill_1
X_2295_ VDD _2295_/Y _3749_/A VSS sg13g2_inv_1
XFILLER_37_420 VDD VSS sg13g2_decap_8
X_4034_ _4227_/B1 VDD _4034_/Y VSS _4227_/A1 _4034_/A2 sg13g2_o21ai_1
XFILLER_112_28 VDD VSS sg13g2_decap_4
XFILLER_37_464 VDD VSS sg13g2_decap_8
XFILLER_24_103 VDD VSS sg13g2_fill_1
XFILLER_52_434 VDD VSS sg13g2_decap_8
XFILLER_40_618 VDD VSS sg13g2_fill_2
XFILLER_80_765 VDD VSS sg13g2_decap_8
XFILLER_33_681 VDD VSS sg13g2_decap_8
X_4936_ fanout333/X VSS VDD _4936_/D _4936_/Q _4941_/CLK sg13g2_dfrbpq_1
XFILLER_20_342 VDD VSS sg13g2_decap_8
XFILLER_21_843 VDD VSS sg13g2_decap_8
X_4867_ fanout326/X VSS VDD _4867_/D _4867_/Q _4868_/CLK sg13g2_dfrbpq_1
XFILLER_21_887 VDD VSS sg13g2_fill_1
X_3818_ _3827_/A VDD _3818_/Y VSS _3820_/B _3817_/X sg13g2_o21ai_1
XFILLER_107_904 VDD VSS sg13g2_decap_8
X_4798_ fanout315/X VSS VDD _4798_/D _4798_/Q _4929_/CLK sg13g2_dfrbpq_1
X_3749_ _3749_/Y _3749_/A _3751_/C VDD VSS sg13g2_xnor2_1
XFILLER_108_7 VDD VSS sg13g2_fill_2
XFILLER_0_725 VDD VSS sg13g2_decap_8
XFILLER_114_480 VDD VSS sg13g2_decap_8
XFILLER_114_491 VDD VSS sg13g2_fill_2
XFILLER_102_653 VDD VSS sg13g2_decap_8
XFILLER_101_152 VDD VSS sg13g2_fill_1
XFILLER_102_686 VDD VSS sg13g2_decap_8
XFILLER_48_729 VDD VSS sg13g2_fill_2
XFILLER_87_397 VDD VSS sg13g2_fill_1
XFILLER_47_239 VDD VSS sg13g2_decap_8
XFILLER_56_740 VDD VSS sg13g2_decap_8
XFILLER_71_710 VDD VSS sg13g2_decap_8
XFILLER_15_158 VDD VSS sg13g2_decap_8
XFILLER_43_445 VDD VSS sg13g2_fill_2
XFILLER_62_21 VDD VSS sg13g2_decap_8
XFILLER_70_231 VDD VSS sg13g2_decap_8
XFILLER_71_776 VDD VSS sg13g2_fill_1
XFILLER_11_364 VDD VSS sg13g2_decap_8
XFILLER_11_375 VDD VSS sg13g2_fill_1
XFILLER_109_230 VDD VSS sg13g2_decap_8
XFILLER_8_869 VDD VSS sg13g2_decap_8
XFILLER_109_252 VDD VSS sg13g2_decap_8
XFILLER_7_379 VDD VSS sg13g2_fill_1
XFILLER_109_296 VDD VSS sg13g2_decap_8
XFILLER_3_541 VDD VSS sg13g2_decap_8
Xclkbuf_4_9_0_clk clkbuf_0_clk/X clkbuf_4_9_0_clk/X VDD VSS sg13g2_buf_8
XFILLER_97_128 VDD VSS sg13g2_decap_8
XFILLER_87_40 VDD VSS sg13g2_fill_2
XFILLER_39_718 VDD VSS sg13g2_fill_2
XFILLER_79_854 VDD VSS sg13g2_decap_8
XFILLER_66_515 VDD VSS sg13g2_fill_2
XFILLER_78_375 VDD VSS sg13g2_decap_8
XFILLER_79_898 VDD VSS sg13g2_decap_4
XFILLER_94_835 VDD VSS sg13g2_decap_8
XFILLER_19_442 VDD VSS sg13g2_decap_4
XFILLER_38_239 VDD VSS sg13g2_fill_1
XFILLER_66_548 VDD VSS sg13g2_decap_8
XFILLER_66_559 VDD VSS sg13g2_fill_2
XFILLER_34_401 VDD VSS sg13g2_decap_8
XFILLER_35_924 VDD VSS sg13g2_fill_2
XFILLER_61_220 VDD VSS sg13g2_decap_8
XFILLER_34_456 VDD VSS sg13g2_decap_8
XFILLER_62_765 VDD VSS sg13g2_decap_8
XFILLER_21_106 VDD VSS sg13g2_decap_8
XFILLER_21_117 VDD VSS sg13g2_decap_4
XFILLER_34_489 VDD VSS sg13g2_decap_4
X_2982_ _3009_/B _4796_/Q _4795_/Q VDD VSS sg13g2_nand2_1
XFILLER_15_692 VDD VSS sg13g2_decap_8
XFILLER_30_640 VDD VSS sg13g2_decap_8
X_4721_ fanout327/X VSS VDD _4721_/D _4721_/Q _4870_/CLK sg13g2_dfrbpq_1
XFILLER_30_651 VDD VSS sg13g2_fill_2
X_4652_ fanout265/X VSS VDD _4652_/D _4652_/Q _4658_/CLK sg13g2_dfrbpq_1
XFILLER_30_695 VDD VSS sg13g2_decap_8
X_3603_ _4723_/Q _4726_/Q _3603_/C _3603_/D _3607_/B VDD VSS sg13g2_and4_1
Xhold803 _3548_/X VDD VSS _4710_/D sg13g2_dlygate4sd3_1
X_4583_ fanout288/X VSS VDD _4583_/D _4583_/Q _4601_/CLK sg13g2_dfrbpq_1
XFILLER_115_211 VDD VSS sg13g2_decap_8
Xhold836 _4326_/Q VDD VSS hold836/X sg13g2_dlygate4sd3_1
Xhold825 _2985_/X VDD VSS _4412_/D sg13g2_dlygate4sd3_1
Xhold814 _4268_/Q VDD VSS hold814/X sg13g2_dlygate4sd3_1
X_3534_ _4696_/Q _3534_/A1 _3552_/S _3534_/X VDD VSS sg13g2_mux2_1
XFILLER_116_789 VDD VSS sg13g2_decap_8
Xhold869 _4488_/Q VDD VSS hold869/X sg13g2_dlygate4sd3_1
Xhold858 _4313_/Q VDD VSS hold858/X sg13g2_dlygate4sd3_1
Xhold847 _4302_/Q VDD VSS hold847/X sg13g2_dlygate4sd3_1
X_3465_ _3483_/B _3481_/C _3465_/A _3465_/Y VDD VSS sg13g2_nand3_1
XFILLER_69_320 VDD VSS sg13g2_decap_8
X_2416_ _2417_/C _2431_/A _2431_/C VDD VSS sg13g2_nand2_1
X_3396_ _3396_/A _3396_/B _3396_/C _3402_/C VDD VSS sg13g2_nor3_1
Xhold1503 _4914_/Q VDD VSS _2433_/C sg13g2_dlygate4sd3_1
Xhold1514 _4629_/Q VDD VSS _3300_/A1 sg13g2_dlygate4sd3_1
Xhold1525 _3619_/X VDD VSS _4731_/D sg13g2_dlygate4sd3_1
X_2347_ VDD _2347_/Y _2347_/A VSS sg13g2_inv_1
XFILLER_97_695 VDD VSS sg13g2_decap_8
XFILLER_85_813 VDD VSS sg13g2_decap_8
XFILLER_111_483 VDD VSS sg13g2_decap_8
XFILLER_69_397 VDD VSS sg13g2_decap_8
XFILLER_84_334 VDD VSS sg13g2_decap_4
Xhold1536 _4631_/Q VDD VSS _3302_/A1 sg13g2_dlygate4sd3_1
Xhold1547 _3564_/Y VDD VSS _4717_/D sg13g2_dlygate4sd3_1
Xhold1558 _4630_/Q VDD VSS _3623_/A1 sg13g2_dlygate4sd3_1
X_2278_ VDD _2278_/Y _3457_/A VSS sg13g2_inv_1
XFILLER_85_857 VDD VSS sg13g2_decap_8
XFILLER_26_924 VDD VSS sg13g2_fill_2
XFILLER_84_356 VDD VSS sg13g2_decap_4
Xhold1569 _3609_/X VDD VSS _4727_/D sg13g2_dlygate4sd3_1
X_4017_ _4017_/Y _4017_/B _4930_/D VDD VSS sg13g2_nand2b_1
XFILLER_65_570 VDD VSS sg13g2_fill_1
XFILLER_52_242 VDD VSS sg13g2_decap_4
XFILLER_53_754 VDD VSS sg13g2_fill_2
XFILLER_40_448 VDD VSS sg13g2_decap_8
X_4919_ fanout261/X VSS VDD _4919_/D _4919_/Q clkload6/A sg13g2_dfrbpq_1
XFILLER_21_684 VDD VSS sg13g2_decap_8
XFILLER_20_194 VDD VSS sg13g2_decap_4
XFILLER_4_305 VDD VSS sg13g2_fill_1
XFILLER_106_255 VDD VSS sg13g2_decap_8
XFILLER_107_789 VDD VSS sg13g2_decap_8
XFILLER_0_522 VDD VSS sg13g2_decap_8
XFILLER_57_21 VDD VSS sg13g2_fill_1
XFILLER_0_599 VDD VSS sg13g2_decap_8
XFILLER_57_54 VDD VSS sg13g2_decap_8
XFILLER_76_857 VDD VSS sg13g2_fill_1
XFILLER_76_879 VDD VSS sg13g2_decap_8
XFILLER_28_272 VDD VSS sg13g2_decap_8
XFILLER_56_581 VDD VSS sg13g2_decap_8
XFILLER_73_42 VDD VSS sg13g2_decap_8
XFILLER_16_489 VDD VSS sg13g2_decap_8
XFILLER_31_459 VDD VSS sg13g2_fill_2
XFILLER_11_172 VDD VSS sg13g2_decap_8
XFILLER_12_684 VDD VSS sg13g2_decap_4
XFILLER_12_695 VDD VSS sg13g2_decap_8
XFILLER_7_110 VDD VSS sg13g2_decap_8
XFILLER_8_633 VDD VSS sg13g2_decap_8
XFILLER_7_187 VDD VSS sg13g2_fill_1
XFILLER_112_214 VDD VSS sg13g2_decap_8
XFILLER_4_872 VDD VSS sg13g2_decap_8
XFILLER_98_426 VDD VSS sg13g2_decap_8
X_3250_ VSS VDD _3278_/A _3250_/A2 _4605_/D _3289_/A sg13g2_a21oi_1
XFILLER_67_835 VDD VSS sg13g2_decap_8
XFILLER_78_150 VDD VSS sg13g2_decap_4
X_3181_ _3181_/B _3181_/A _3181_/X VDD VSS sg13g2_xor2_1
XFILLER_78_194 VDD VSS sg13g2_decap_8
XFILLER_94_654 VDD VSS sg13g2_fill_2
XFILLER_54_518 VDD VSS sg13g2_decap_8
XFILLER_34_264 VDD VSS sg13g2_decap_8
XFILLER_22_437 VDD VSS sg13g2_fill_1
XFILLER_97_0 VDD VSS sg13g2_decap_8
X_4704_ fanout306/X VSS VDD _4704_/D _4704_/Q _4869_/CLK sg13g2_dfrbpq_1
X_2965_ hold969/X _3094_/A0 _2981_/S _2965_/X VDD VSS sg13g2_mux2_1
X_2896_ _2896_/A0 _3104_/A0 _2896_/S _4329_/D VDD VSS sg13g2_mux2_1
X_4635_ fanout251/X VSS VDD _4635_/D _4635_/Q clkload3/A sg13g2_dfrbpq_1
Xhold600 _4002_/Y VDD VSS _4837_/D sg13g2_dlygate4sd3_1
Xhold611 _4558_/Q VDD VSS _3140_/A sg13g2_dlygate4sd3_1
X_4566_ fanout329/X VSS VDD _4566_/D _4566_/Q _4955_/CLK sg13g2_dfrbpq_1
Xhold622 _4889_/Q VDD VSS _2576_/A sg13g2_dlygate4sd3_1
Xhold633 _3346_/Y VDD VSS _4633_/D sg13g2_dlygate4sd3_1
Xhold644 _4955_/Q VDD VSS _4017_/B sg13g2_dlygate4sd3_1
X_3517_ _2655_/A VDD _3518_/B VSS _2655_/B _3513_/B sg13g2_o21ai_1
XFILLER_103_203 VDD VSS sg13g2_decap_8
Xhold688 _2565_/Y VDD VSS _2568_/A sg13g2_dlygate4sd3_1
Xhold677 _2782_/Y VDD VSS _4940_/D sg13g2_dlygate4sd3_1
Xhold666 _4879_/Q VDD VSS _2550_/A sg13g2_dlygate4sd3_1
Xhold655 _4806_/Q VDD VSS _2476_/C sg13g2_dlygate4sd3_1
X_4497_ fanout307/X VSS VDD _4497_/D _4497_/Q _4978_/CLK sg13g2_dfrbpq_1
Xhold699 _4892_/Q VDD VSS _2583_/B sg13g2_dlygate4sd3_1
X_3448_ _3447_/Y VDD _4661_/D VSS _2265_/Y _3447_/C sg13g2_o21ai_1
Xhold1300 _4448_/Q VDD VSS _3022_/A0 sg13g2_dlygate4sd3_1
X_3379_ _3374_/Y VDD _3423_/B VSS _3377_/Y _3424_/C sg13g2_o21ai_1
XFILLER_111_280 VDD VSS sg13g2_fill_2
XFILLER_57_312 VDD VSS sg13g2_decap_8
XFILLER_69_172 VDD VSS sg13g2_decap_8
Xhold1311 _4854_/Q VDD VSS hold1311/X sg13g2_dlygate4sd3_1
Xhold1322 _3766_/Y VDD VSS _4767_/D sg13g2_dlygate4sd3_1
Xhold1333 _4810_/Q VDD VSS _3902_/C sg13g2_dlygate4sd3_1
XFILLER_85_621 VDD VSS sg13g2_decap_8
XFILLER_27_35 VDD VSS sg13g2_decap_8
Xhold1344 _3956_/Y VDD VSS _4822_/D sg13g2_dlygate4sd3_1
Xhold1355 _3434_/Y VDD VSS _4654_/D sg13g2_dlygate4sd3_1
Xhold1366 _4944_/Q VDD VSS _2724_/B sg13g2_dlygate4sd3_1
Xhold1377 _3462_/Y VDD VSS _4668_/D sg13g2_dlygate4sd3_1
XFILLER_38_581 VDD VSS sg13g2_decap_8
XFILLER_72_315 VDD VSS sg13g2_decap_8
XFILLER_73_849 VDD VSS sg13g2_decap_8
Xhold1388 _4668_/Q VDD VSS _3459_/A sg13g2_dlygate4sd3_1
Xhold1399 _3362_/Y VDD VSS _4638_/D sg13g2_dlygate4sd3_1
XFILLER_25_242 VDD VSS sg13g2_fill_2
XFILLER_53_540 VDD VSS sg13g2_fill_2
XFILLER_25_253 VDD VSS sg13g2_decap_4
XFILLER_40_201 VDD VSS sg13g2_decap_8
XFILLER_41_702 VDD VSS sg13g2_fill_1
XFILLER_41_724 VDD VSS sg13g2_decap_8
XFILLER_9_408 VDD VSS sg13g2_decap_8
XFILLER_107_520 VDD VSS sg13g2_decap_4
XFILLER_5_636 VDD VSS sg13g2_decap_8
XFILLER_107_564 VDD VSS sg13g2_decap_8
XFILLER_4_157 VDD VSS sg13g2_fill_2
XFILLER_4_28 VDD VSS sg13g2_decap_8
XFILLER_1_831 VDD VSS sg13g2_decap_8
XFILLER_68_53 VDD VSS sg13g2_decap_8
XFILLER_96_919 VDD VSS sg13g2_decap_8
XFILLER_103_770 VDD VSS sg13g2_fill_1
XFILLER_95_407 VDD VSS sg13g2_decap_8
XFILLER_0_396 VDD VSS sg13g2_decap_8
XFILLER_49_857 VDD VSS sg13g2_decap_8
XFILLER_36_518 VDD VSS sg13g2_decap_8
XFILLER_48_378 VDD VSS sg13g2_decap_8
XFILLER_75_142 VDD VSS sg13g2_decap_8
XFILLER_76_665 VDD VSS sg13g2_decap_8
XFILLER_63_315 VDD VSS sg13g2_decap_8
XFILLER_64_838 VDD VSS sg13g2_decap_8
XFILLER_91_624 VDD VSS sg13g2_decap_8
XFILLER_17_765 VDD VSS sg13g2_fill_1
XFILLER_44_551 VDD VSS sg13g2_decap_8
XFILLER_16_253 VDD VSS sg13g2_fill_2
XFILLER_16_264 VDD VSS sg13g2_decap_8
XFILLER_31_212 VDD VSS sg13g2_decap_8
XFILLER_90_7 VDD VSS sg13g2_decap_8
XFILLER_32_779 VDD VSS sg13g2_decap_4
X_2750_ _2751_/A _2751_/B _2750_/Y VDD VSS sg13g2_nor2_1
X_2681_ _2682_/B _2680_/X _3511_/A _2679_/Y _2678_/Y VDD VSS sg13g2_a22oi_1
XFILLER_69_4 VDD VSS sg13g2_fill_1
X_4420_ _4420_/RESET_B VSS VDD _4420_/D _4420_/Q _4552_/CLK sg13g2_dfrbpq_1
X_4351_ _4351_/RESET_B VSS VDD _4351_/D _4351_/Q _4961_/CLK sg13g2_dfrbpq_1
X_4282_ _4282_/RESET_B VSS VDD _4282_/D _4282_/Q clkload8/A sg13g2_dfrbpq_1
X_3302_ _3437_/A _3302_/A1 _3370_/S _4631_/D VDD VSS sg13g2_mux2_1
XFILLER_98_245 VDD VSS sg13g2_decap_8
XFILLER_101_729 VDD VSS sg13g2_decap_8
XFILLER_67_610 VDD VSS sg13g2_fill_1
XFILLER_79_470 VDD VSS sg13g2_decap_8
X_3233_ VSS VDD hold732/X _3232_/Y _3233_/Y _3192_/X sg13g2_a21oi_1
XFILLER_98_289 VDD VSS sg13g2_decap_8
XFILLER_39_334 VDD VSS sg13g2_decap_8
XFILLER_104_29 VDD VSS sg13g2_fill_1
XFILLER_12_0 VDD VSS sg13g2_decap_8
XFILLER_55_816 VDD VSS sg13g2_decap_8
XFILLER_66_142 VDD VSS sg13g2_decap_4
X_3164_ _2259_/A VDD _3164_/Y VSS _2258_/A _3162_/B sg13g2_o21ai_1
X_3095_ _3095_/A0 hold946/X _3104_/S _4519_/D VDD VSS sg13g2_mux2_1
XFILLER_54_348 VDD VSS sg13g2_decap_8
XFILLER_81_156 VDD VSS sg13g2_fill_2
XFILLER_35_584 VDD VSS sg13g2_decap_4
XFILLER_22_234 VDD VSS sg13g2_decap_8
XFILLER_50_532 VDD VSS sg13g2_decap_8
XFILLER_62_381 VDD VSS sg13g2_decap_8
Xfanout27 _3805_/X _3827_/A VDD VSS sg13g2_buf_1
Xfanout38 _3976_/Y _3985_/B VDD VSS sg13g2_buf_1
XFILLER_11_908 VDD VSS sg13g2_decap_8
Xfanout49 _3344_/Y _3483_/C VDD VSS sg13g2_buf_1
X_3997_ _3997_/Y _3997_/A _4003_/B VDD VSS sg13g2_nand2_1
X_2948_ hold964/X _3103_/A0 _2949_/S _2948_/X VDD VSS sg13g2_mux2_1
XFILLER_108_306 VDD VSS sg13g2_decap_8
XFILLER_109_818 VDD VSS sg13g2_decap_8
X_4618_ fanout281/X VSS VDD _4618_/D _4618_/Q _4946_/CLK sg13g2_dfrbpq_1
X_2879_ _2879_/A0 _3087_/A0 _2902_/S _4312_/D VDD VSS sg13g2_mux2_1
XFILLER_104_512 VDD VSS sg13g2_fill_2
X_4549_ fanout297/X VSS VDD _4549_/D _4549_/Q _4960_/CLK sg13g2_dfrbpq_1
XFILLER_116_394 VDD VSS sg13g2_decap_8
XFILLER_78_919 VDD VSS sg13g2_decap_8
XFILLER_89_223 VDD VSS sg13g2_decap_8
XFILLER_49_109 VDD VSS sg13g2_decap_8
XFILLER_58_643 VDD VSS sg13g2_decap_8
XFILLER_100_762 VDD VSS sg13g2_decap_8
XFILLER_38_56 VDD VSS sg13g2_decap_8
Xhold1130 _4408_/Q VDD VSS _2979_/A0 sg13g2_dlygate4sd3_1
Xhold1141 _4533_/Q VDD VSS _3033_/A1 sg13g2_dlygate4sd3_1
XFILLER_100_784 VDD VSS sg13g2_decap_8
XFILLER_57_164 VDD VSS sg13g2_decap_8
XFILLER_57_186 VDD VSS sg13g2_fill_1
XFILLER_58_687 VDD VSS sg13g2_decap_8
Xhold1152 _4715_/Q VDD VSS _3553_/A0 sg13g2_dlygate4sd3_1
Xhold1163 _3714_/Y VDD VSS _4753_/D sg13g2_dlygate4sd3_1
Xhold1174 _4594_/Q VDD VSS _3222_/A sg13g2_dlygate4sd3_1
Xhold1185 _4433_/Q VDD VSS _3006_/A0 sg13g2_dlygate4sd3_1
XFILLER_45_337 VDD VSS sg13g2_fill_1
XFILLER_45_348 VDD VSS sg13g2_decap_4
XFILLER_72_123 VDD VSS sg13g2_decap_8
Xhold1196 _2840_/X VDD VSS _4277_/D sg13g2_dlygate4sd3_1
XFILLER_14_713 VDD VSS sg13g2_fill_2
XFILLER_26_562 VDD VSS sg13g2_fill_1
XFILLER_60_307 VDD VSS sg13g2_decap_8
XFILLER_72_189 VDD VSS sg13g2_decap_8
XFILLER_13_201 VDD VSS sg13g2_decap_8
XFILLER_41_554 VDD VSS sg13g2_decap_8
XFILLER_9_249 VDD VSS sg13g2_fill_2
Xclkload19 clkload19/Y _4601_/CLK VDD VSS sg13g2_inv_2
XFILLER_114_309 VDD VSS sg13g2_decap_8
XFILLER_68_418 VDD VSS sg13g2_decap_8
XFILLER_95_215 VDD VSS sg13g2_decap_4
XFILLER_49_643 VDD VSS sg13g2_decap_4
XFILLER_95_40 VDD VSS sg13g2_fill_1
XFILLER_0_182 VDD VSS sg13g2_decap_8
XFILLER_76_440 VDD VSS sg13g2_decap_8
XFILLER_36_315 VDD VSS sg13g2_decap_4
XFILLER_48_164 VDD VSS sg13g2_fill_1
XFILLER_49_687 VDD VSS sg13g2_decap_8
XFILLER_63_101 VDD VSS sg13g2_decap_8
XFILLER_36_348 VDD VSS sg13g2_decap_4
XFILLER_52_808 VDD VSS sg13g2_decap_4
XFILLER_91_443 VDD VSS sg13g2_decap_8
XFILLER_64_679 VDD VSS sg13g2_decap_8
X_3920_ VSS VDD _3952_/B1 _3924_/C _3923_/A _3930_/A sg13g2_a21oi_1
XFILLER_91_476 VDD VSS sg13g2_decap_8
XFILLER_32_521 VDD VSS sg13g2_decap_8
XFILLER_32_576 VDD VSS sg13g2_fill_2
X_3851_ _3852_/B _4772_/Q _3851_/B VDD VSS sg13g2_nand2_1
X_3782_ _3786_/A _3786_/C _3782_/Y VDD VSS sg13g2_nor2_1
X_2802_ _2809_/A VDD _2802_/Y VSS _2406_/B _2801_/B sg13g2_o21ai_1
X_2733_ _2733_/A _2733_/B _2733_/Y VDD VSS sg13g2_nor2_1
X_2664_ VDD VSS _2663_/Y _3514_/A _2660_/Y _3511_/A _2664_/Y _2657_/X sg13g2_a221oi_1
X_4403_ _4403_/RESET_B VSS VDD _4403_/D _4403_/Q _4729_/CLK sg13g2_dfrbpq_1
X_2595_ _3217_/B _3215_/B _3215_/A VDD VSS sg13g2_nand2b_1
XFILLER_113_320 VDD VSS sg13g2_decap_4
XFILLER_5_71 VDD VSS sg13g2_decap_8
X_4334_ _4334_/RESET_B VSS VDD _4334_/D _4334_/Q _4971_/CLK sg13g2_dfrbpq_1
XFILLER_115_28 VDD VSS sg13g2_fill_2
XFILLER_59_407 VDD VSS sg13g2_decap_8
XFILLER_59_429 VDD VSS sg13g2_fill_2
Xfanout206 _4741_/Q _3719_/A VDD VSS sg13g2_buf_1
Xfanout217 _4684_/Q _2330_/A VDD VSS sg13g2_buf_1
Xfanout228 hold1428/X _3103_/A0 VDD VSS sg13g2_buf_1
XFILLER_99_565 VDD VSS sg13g2_decap_8
XFILLER_87_705 VDD VSS sg13g2_decap_8
XFILLER_101_548 VDD VSS sg13g2_decap_8
Xfanout239 _4516_/Q _3092_/A0 VDD VSS sg13g2_buf_1
X_4265_ _4265_/RESET_B VSS VDD _4265_/D _4265_/Q _4559_/CLK sg13g2_dfrbpq_1
XFILLER_39_131 VDD VSS sg13g2_decap_8
XFILLER_67_440 VDD VSS sg13g2_decap_8
X_4196_ _4196_/B1 VDD _4196_/Y VSS _4196_/A1 _4454_/Q sg13g2_o21ai_1
X_3216_ _3192_/A VDD _4591_/D VSS _2604_/A _3216_/A2 sg13g2_o21ai_1
XFILLER_28_827 VDD VSS sg13g2_decap_8
X_3147_ _3147_/B _3147_/A _3147_/X VDD VSS sg13g2_xor2_1
XFILLER_39_197 VDD VSS sg13g2_decap_8
XFILLER_54_123 VDD VSS sg13g2_decap_8
XFILLER_55_646 VDD VSS sg13g2_decap_4
XFILLER_54_156 VDD VSS sg13g2_decap_8
XFILLER_70_616 VDD VSS sg13g2_fill_2
X_3078_ _4192_/B hold908/X _3079_/S _4502_/D VDD VSS sg13g2_mux2_1
XFILLER_24_14 VDD VSS sg13g2_fill_2
XFILLER_36_893 VDD VSS sg13g2_decap_8
XFILLER_11_738 VDD VSS sg13g2_decap_8
XFILLER_50_373 VDD VSS sg13g2_decap_8
XFILLER_51_885 VDD VSS sg13g2_fill_2
XFILLER_10_259 VDD VSS sg13g2_decap_8
XFILLER_109_648 VDD VSS sg13g2_fill_2
XFILLER_6_219 VDD VSS sg13g2_decap_8
XFILLER_108_169 VDD VSS sg13g2_decap_8
XFILLER_2_436 VDD VSS sg13g2_fill_2
XFILLER_104_386 VDD VSS sg13g2_decap_8
XFILLER_49_77 VDD VSS sg13g2_fill_2
XFILLER_49_88 VDD VSS sg13g2_decap_8
XFILLER_77_215 VDD VSS sg13g2_decap_8
XFILLER_93_708 VDD VSS sg13g2_decap_8
XFILLER_65_21 VDD VSS sg13g2_decap_8
XFILLER_92_218 VDD VSS sg13g2_fill_1
XFILLER_86_793 VDD VSS sg13g2_fill_1
XFILLER_86_771 VDD VSS sg13g2_decap_8
XFILLER_18_337 VDD VSS sg13g2_fill_2
XFILLER_34_808 VDD VSS sg13g2_decap_8
XFILLER_45_123 VDD VSS sg13g2_decap_8
XFILLER_58_495 VDD VSS sg13g2_fill_1
XFILLER_73_454 VDD VSS sg13g2_fill_1
XFILLER_65_98 VDD VSS sg13g2_decap_8
XFILLER_26_381 VDD VSS sg13g2_decap_8
XFILLER_45_189 VDD VSS sg13g2_decap_8
XFILLER_60_137 VDD VSS sg13g2_decap_8
XFILLER_14_565 VDD VSS sg13g2_decap_8
XFILLER_41_362 VDD VSS sg13g2_decap_4
XFILLER_41_384 VDD VSS sg13g2_decap_8
XFILLER_42_885 VDD VSS sg13g2_decap_4
XFILLER_81_97 VDD VSS sg13g2_decap_8
XFILLER_5_230 VDD VSS sg13g2_decap_8
XFILLER_6_742 VDD VSS sg13g2_decap_8
XFILLER_114_117 VDD VSS sg13g2_fill_1
XFILLER_53_7 VDD VSS sg13g2_decap_8
XFILLER_5_241 VDD VSS sg13g2_fill_1
XFILLER_30_90 VDD VSS sg13g2_decap_8
XFILLER_5_274 VDD VSS sg13g2_decap_8
X_2380_ _2382_/C _4663_/Q _4655_/Q VDD VSS sg13g2_xnor2_1
XFILLER_111_857 VDD VSS sg13g2_decap_4
XFILLER_68_259 VDD VSS sg13g2_decap_8
X_4050_ _4049_/Y VDD _4056_/B VSS _4046_/Y _4047_/Y sg13g2_o21ai_1
XFILLER_65_911 VDD VSS sg13g2_decap_8
XFILLER_76_270 VDD VSS sg13g2_decap_8
Xinput6 slot_sel[1] input6/X VDD VSS sg13g2_buf_1
X_3001_ _3001_/A0 _3103_/A0 _3002_/S _3001_/X VDD VSS sg13g2_mux2_1
XFILLER_37_646 VDD VSS sg13g2_decap_8
XFILLER_64_443 VDD VSS sg13g2_fill_2
XFILLER_24_318 VDD VSS sg13g2_fill_1
XFILLER_80_914 VDD VSS sg13g2_decap_8
XFILLER_80_925 VDD VSS sg13g2_fill_1
XFILLER_92_763 VDD VSS sg13g2_decap_8
XFILLER_17_370 VDD VSS sg13g2_fill_1
X_4952_ fanout275/X VSS VDD _4952_/D _4952_/Q _4954_/CLK sg13g2_dfrbpq_1
XFILLER_33_863 VDD VSS sg13g2_decap_8
X_4883_ fanout303/X VSS VDD _4883_/D _4883_/Q _4884_/CLK sg13g2_dfrbpq_1
X_3903_ _3904_/B _3911_/B _3907_/C VDD VSS sg13g2_nand2_1
XFILLER_60_693 VDD VSS sg13g2_fill_1
X_3834_ _4785_/D _3837_/B1 _3833_/Y _3837_/A2 _3396_/A VDD VSS sg13g2_a22oi_1
X_3765_ _3765_/Y _3835_/A _3765_/B VDD VSS sg13g2_xnor2_1
X_3696_ _3694_/Y VDD _3697_/B VSS _3679_/Y _3695_/Y sg13g2_o21ai_1
X_2716_ _3493_/A _4648_/Q _3307_/B VDD VSS sg13g2_nor2b_1
XFILLER_106_629 VDD VSS sg13g2_decap_8
X_2647_ VDD _4858_/D _2647_/A VSS sg13g2_inv_1
XFILLER_10_49 VDD VSS sg13g2_decap_8
XFILLER_0_907 VDD VSS sg13g2_decap_8
XFILLER_114_673 VDD VSS sg13g2_decap_8
X_2578_ _2583_/D _2583_/A _4891_/D VDD VSS sg13g2_xor2_1
XFILLER_101_323 VDD VSS sg13g2_decap_8
XFILLER_102_835 VDD VSS sg13g2_decap_8
XFILLER_113_161 VDD VSS sg13g2_decap_8
X_4317_ _4317_/RESET_B VSS VDD _4317_/D _4317_/Q _4973_/CLK sg13g2_dfrbpq_1
XFILLER_19_14 VDD VSS sg13g2_decap_8
XFILLER_56_900 VDD VSS sg13g2_decap_8
XFILLER_75_719 VDD VSS sg13g2_decap_8
X_4248_ _4251_/S _4285_/Q _4310_/Q _4335_/Q _4360_/Q _4250_/B1 _4248_/X VDD VSS sg13g2_mux4_1
XFILLER_28_613 VDD VSS sg13g2_decap_8
XFILLER_74_229 VDD VSS sg13g2_decap_8
XFILLER_27_123 VDD VSS sg13g2_decap_4
X_4179_ _4179_/Y _4179_/B _4227_/B1 VDD VSS sg13g2_nand2b_1
XFILLER_95_590 VDD VSS sg13g2_fill_2
XFILLER_43_616 VDD VSS sg13g2_decap_8
XFILLER_55_476 VDD VSS sg13g2_decap_8
XFILLER_70_402 VDD VSS sg13g2_decap_4
XFILLER_71_903 VDD VSS sg13g2_decap_8
XFILLER_82_262 VDD VSS sg13g2_decap_8
XFILLER_83_785 VDD VSS sg13g2_decap_8
XFILLER_36_690 VDD VSS sg13g2_decap_8
XFILLER_70_424 VDD VSS sg13g2_decap_4
XFILLER_42_148 VDD VSS sg13g2_fill_2
XFILLER_51_682 VDD VSS sg13g2_decap_8
XFILLER_109_401 VDD VSS sg13g2_decap_8
XFILLER_11_568 VDD VSS sg13g2_fill_1
XFILLER_11_579 VDD VSS sg13g2_decap_8
XFILLER_7_528 VDD VSS sg13g2_decap_8
X_4398__528 VDD VSS _4398_/RESET_B sg13g2_tiehi
XFILLER_109_489 VDD VSS sg13g2_decap_8
XFILLER_2_222 VDD VSS sg13g2_decap_4
XFILLER_3_723 VDD VSS sg13g2_decap_8
XFILLER_105_695 VDD VSS sg13g2_decap_8
XFILLER_78_568 VDD VSS sg13g2_decap_8
XFILLER_65_229 VDD VSS sg13g2_decap_8
XFILLER_19_657 VDD VSS sg13g2_fill_2
XFILLER_74_741 VDD VSS sg13g2_fill_2
XFILLER_34_616 VDD VSS sg13g2_fill_1
XFILLER_62_925 VDD VSS sg13g2_fill_1
XFILLER_73_240 VDD VSS sg13g2_fill_1
XFILLER_33_126 VDD VSS sg13g2_fill_1
XFILLER_34_649 VDD VSS sg13g2_decap_8
XFILLER_61_413 VDD VSS sg13g2_decap_8
XFILLER_92_63 VDD VSS sg13g2_decap_8
XFILLER_14_340 VDD VSS sg13g2_decap_8
XFILLER_92_96 VDD VSS sg13g2_decap_8
XFILLER_30_822 VDD VSS sg13g2_decap_8
XFILLER_42_660 VDD VSS sg13g2_decap_8
XFILLER_41_170 VDD VSS sg13g2_decap_8
X_3550_ _4712_/Q _3550_/A1 _3550_/S _3550_/X VDD VSS sg13g2_mux2_1
XFILLER_115_404 VDD VSS sg13g2_decap_8
X_2501_ _2501_/A _4898_/Q _2501_/Y VDD VSS sg13g2_nor2b_1
XFILLER_6_594 VDD VSS sg13g2_decap_4
X_3481_ _3483_/B _3481_/C _3481_/A _3481_/Y VDD VSS sg13g2_nand3_1
X_2432_ _4914_/Q _2437_/B _2432_/C _2805_/B _2438_/B VDD VSS sg13g2_or4_1
X_2363_ VSS VDD _2363_/X _4654_/Q _4662_/Q sg13g2_or2_1
XFILLER_111_643 VDD VSS sg13g2_decap_8
X_4102_ _4197_/S _4270_/Q _4295_/Q _4320_/Q _4345_/Q _4196_/B1 _4102_/X VDD VSS sg13g2_mux4_1
XFILLER_38_911 VDD VSS sg13g2_decap_8
XFILLER_56_218 VDD VSS sg13g2_decap_8
X_4033_ VSS VDD _4225_/A1 _4031_/X _4033_/Y _4032_/Y sg13g2_a21oi_1
X_2294_ VDD _2294_/Y _3768_/A VSS sg13g2_inv_1
XFILLER_96_398 VDD VSS sg13g2_decap_8
XFILLER_2_72 VDD VSS sg13g2_fill_2
XFILLER_2_83 VDD VSS sg13g2_decap_8
XFILLER_37_410 VDD VSS sg13g2_fill_1
XFILLER_53_925 VDD VSS sg13g2_fill_1
XFILLER_37_498 VDD VSS sg13g2_fill_1
XFILLER_52_413 VDD VSS sg13g2_decap_8
XFILLER_65_796 VDD VSS sg13g2_decap_4
XFILLER_80_744 VDD VSS sg13g2_decap_8
XFILLER_24_159 VDD VSS sg13g2_decap_8
X_4935_ fanout333/X VSS VDD _4935_/D _4935_/Q _4941_/CLK sg13g2_dfrbpq_1
XFILLER_20_321 VDD VSS sg13g2_decap_8
X_4866_ fanout326/X VSS VDD _4866_/D _4866_/Q _4868_/CLK sg13g2_dfrbpq_1
X_4797_ fanout313/X VSS VDD _4797_/D _4797_/Q _4929_/CLK sg13g2_dfrbpq_1
X_3817_ _4761_/Q _3817_/B _3817_/X VDD VSS sg13g2_and2_1
XFILLER_20_398 VDD VSS sg13g2_decap_8
X_3748_ _3748_/Y _3749_/A _3758_/B VDD VSS sg13g2_nand2_1
XFILLER_21_48 VDD VSS sg13g2_decap_8
X_3679_ _4735_/Q _3680_/B _3679_/Y VDD VSS sg13g2_nor2_1
XFILLER_0_704 VDD VSS sg13g2_decap_8
XFILLER_88_822 VDD VSS sg13g2_decap_8
XFILLER_101_131 VDD VSS sg13g2_decap_8
XFILLER_48_708 VDD VSS sg13g2_decap_8
XFILLER_88_877 VDD VSS sg13g2_decap_8
XFILLER_29_911 VDD VSS sg13g2_decap_8
XFILLER_87_376 VDD VSS sg13g2_decap_8
XFILLER_101_186 VDD VSS sg13g2_decap_8
XFILLER_28_476 VDD VSS sg13g2_fill_1
XFILLER_44_925 VDD VSS sg13g2_fill_1
XFILLER_46_67 VDD VSS sg13g2_decap_8
XFILLER_43_424 VDD VSS sg13g2_decap_8
XFILLER_55_295 VDD VSS sg13g2_decap_8
XFILLER_70_210 VDD VSS sg13g2_decap_8
XFILLER_15_137 VDD VSS sg13g2_decap_8
XFILLER_102_84 VDD VSS sg13g2_decap_8
XFILLER_30_118 VDD VSS sg13g2_decap_8
XFILLER_23_170 VDD VSS sg13g2_fill_1
XFILLER_30_129 VDD VSS sg13g2_fill_1
XFILLER_62_88 VDD VSS sg13g2_decap_4
Xclkbuf_leaf_50_clk clkbuf_4_8_0_clk/X _4966_/CLK VDD VSS sg13g2_buf_8
XFILLER_12_888 VDD VSS sg13g2_decap_8
XFILLER_8_848 VDD VSS sg13g2_decap_8
XFILLER_79_833 VDD VSS sg13g2_decap_8
XFILLER_87_74 VDD VSS sg13g2_decap_8
XFILLER_66_527 VDD VSS sg13g2_decap_8
XFILLER_94_814 VDD VSS sg13g2_decap_8
XFILLER_35_903 VDD VSS sg13g2_decap_8
XFILLER_46_284 VDD VSS sg13g2_decap_8
XFILLER_47_785 VDD VSS sg13g2_decap_8
XFILLER_74_571 VDD VSS sg13g2_fill_1
XFILLER_74_582 VDD VSS sg13g2_decap_8
XFILLER_62_744 VDD VSS sg13g2_decap_8
XFILLER_22_619 VDD VSS sg13g2_decap_8
XFILLER_61_287 VDD VSS sg13g2_decap_8
X_2981_ _2981_/A0 _3110_/A0 _2981_/S _2981_/X VDD VSS sg13g2_mux2_1
Xclkbuf_leaf_41_clk clkbuf_4_9_0_clk/X _4967_/CLK VDD VSS sg13g2_buf_8
X_4720_ fanout327/X VSS VDD _4720_/D _4720_/Q _4870_/CLK sg13g2_dfrbpq_1
XFILLER_30_674 VDD VSS sg13g2_decap_8
X_4651_ fanout265/X VSS VDD _4651_/D _4651_/Q _4658_/CLK sg13g2_dfrbpq_1
X_3602_ _3602_/B _3603_/D _3602_/A _3604_/B VDD VSS sg13g2_nand3_1
XFILLER_116_713 VDD VSS sg13g2_fill_1
X_4582_ fanout288/X VSS VDD _4582_/D _4582_/Q _4601_/CLK sg13g2_dfrbpq_1
XFILLER_116_724 VDD VSS sg13g2_decap_4
Xhold837 _2893_/X VDD VSS _4326_/D sg13g2_dlygate4sd3_1
Xhold826 _4321_/Q VDD VSS hold826/X sg13g2_dlygate4sd3_1
Xhold815 _4755_/Q VDD VSS _2345_/A sg13g2_dlygate4sd3_1
Xhold804 _4663_/Q VDD VSS _3449_/A sg13g2_dlygate4sd3_1
X_3533_ _4695_/Q _3533_/A1 _3550_/S _3533_/X VDD VSS sg13g2_mux2_1
XFILLER_116_768 VDD VSS sg13g2_decap_8
XFILLER_42_0 VDD VSS sg13g2_decap_8
Xhold859 _2880_/X VDD VSS _4313_/D sg13g2_dlygate4sd3_1
Xhold848 _2867_/X VDD VSS _4302_/D sg13g2_dlygate4sd3_1
X_3464_ _3463_/Y VDD _4669_/D VSS _2282_/Y _3481_/C sg13g2_o21ai_1
XFILLER_89_619 VDD VSS sg13g2_fill_1
XFILLER_103_429 VDD VSS sg13g2_decap_8
XFILLER_115_278 VDD VSS sg13g2_decap_8
X_2415_ VDD _2431_/D _2429_/B VSS sg13g2_inv_1
XFILLER_88_118 VDD VSS sg13g2_decap_8
X_3395_ _3421_/A _3410_/C _3395_/B VDD VSS sg13g2_nand2_1
XFILLER_97_630 VDD VSS sg13g2_decap_8
XFILLER_111_462 VDD VSS sg13g2_fill_1
XFILLER_69_376 VDD VSS sg13g2_decap_8
XFILLER_84_313 VDD VSS sg13g2_decap_8
Xhold1504 _2439_/Y VDD VSS _2440_/B sg13g2_dlygate4sd3_1
Xhold1515 _4588_/Q VDD VSS _3208_/A sg13g2_dlygate4sd3_1
Xhold1526 _4861_/Q VDD VSS _3570_/A sg13g2_dlygate4sd3_1
X_2346_ VDD _2346_/Y _4038_/A VSS sg13g2_inv_1
XFILLER_97_674 VDD VSS sg13g2_decap_8
XFILLER_85_836 VDD VSS sg13g2_fill_1
Xhold1537 _4643_/Q VDD VSS _3651_/A1 sg13g2_dlygate4sd3_1
Xhold1548 _4568_/Q VDD VSS _2258_/A sg13g2_dlygate4sd3_1
Xhold1559 _4646_/Q VDD VSS _3370_/A1 sg13g2_dlygate4sd3_1
X_2277_ VDD _2277_/Y _4675_/Q VSS sg13g2_inv_1
XFILLER_37_240 VDD VSS sg13g2_fill_2
XFILLER_37_251 VDD VSS sg13g2_decap_8
X_4016_ _4930_/D VDD _4016_/Y VSS _4189_/B1 _4010_/X sg13g2_o21ai_1
XFILLER_37_295 VDD VSS sg13g2_decap_8
XFILLER_52_232 VDD VSS sg13g2_decap_4
XFILLER_80_541 VDD VSS sg13g2_decap_8
XFILLER_25_468 VDD VSS sg13g2_decap_8
Xclkbuf_leaf_32_clk clkbuf_4_15_0_clk/X _4933_/CLK VDD VSS sg13g2_buf_8
X_4918_ fanout261/X VSS VDD _4918_/D _4918_/Q clkload6/A sg13g2_dfrbpq_1
XFILLER_21_663 VDD VSS sg13g2_decap_8
XFILLER_32_14 VDD VSS sg13g2_decap_8
X_4849_ fanout331/X VSS VDD _4849_/D _4849_/Q _4933_/CLK sg13g2_dfrbpq_1
XFILLER_107_768 VDD VSS sg13g2_decap_8
XFILLER_0_501 VDD VSS sg13g2_decap_8
XFILLER_79_107 VDD VSS sg13g2_decap_8
XFILLER_115_790 VDD VSS sg13g2_decap_8
XFILLER_0_578 VDD VSS sg13g2_decap_8
XFILLER_75_335 VDD VSS sg13g2_fill_1
XFILLER_87_173 VDD VSS sg13g2_decap_8
XFILLER_91_828 VDD VSS sg13g2_decap_8
XFILLER_16_424 VDD VSS sg13g2_fill_2
XFILLER_17_925 VDD VSS sg13g2_fill_1
XFILLER_28_251 VDD VSS sg13g2_decap_8
XFILLER_44_733 VDD VSS sg13g2_decap_8
XFILLER_56_560 VDD VSS sg13g2_decap_8
XFILLER_73_21 VDD VSS sg13g2_decap_8
XFILLER_16_468 VDD VSS sg13g2_decap_8
XFILLER_31_405 VDD VSS sg13g2_decap_8
XFILLER_31_416 VDD VSS sg13g2_fill_2
XFILLER_43_276 VDD VSS sg13g2_decap_8
XFILLER_31_438 VDD VSS sg13g2_decap_8
XFILLER_71_596 VDD VSS sg13g2_decap_8
Xclkbuf_leaf_23_clk clkbuf_4_12_0_clk/X _4973_/CLK VDD VSS sg13g2_buf_8
XFILLER_8_612 VDD VSS sg13g2_decap_8
XFILLER_11_151 VDD VSS sg13g2_decap_8
XFILLER_11_195 VDD VSS sg13g2_fill_1
XFILLER_4_851 VDD VSS sg13g2_decap_8
XFILLER_99_917 VDD VSS sg13g2_decap_8
XFILLER_113_738 VDD VSS sg13g2_decap_8
XFILLER_113_749 VDD VSS sg13g2_decap_4
XFILLER_39_516 VDD VSS sg13g2_decap_8
XFILLER_66_302 VDD VSS sg13g2_decap_8
XFILLER_67_814 VDD VSS sg13g2_decap_8
X_3180_ _3180_/Y _3184_/B _3179_/Y VDD VSS sg13g2_nand2b_1
XFILLER_94_600 VDD VSS sg13g2_decap_8
XFILLER_39_527 VDD VSS sg13g2_fill_1
XFILLER_78_173 VDD VSS sg13g2_decap_8
XFILLER_54_508 VDD VSS sg13g2_fill_1
XFILLER_66_346 VDD VSS sg13g2_decap_4
XFILLER_81_305 VDD VSS sg13g2_decap_8
XFILLER_19_251 VDD VSS sg13g2_fill_2
XFILLER_75_891 VDD VSS sg13g2_fill_2
XFILLER_34_210 VDD VSS sg13g2_decap_4
XFILLER_35_755 VDD VSS sg13g2_decap_8
XFILLER_62_552 VDD VSS sg13g2_decap_4
XFILLER_50_736 VDD VSS sg13g2_decap_8
X_2964_ _2964_/A0 _3017_/A1 _2979_/S _4393_/D VDD VSS sg13g2_mux2_1
Xclkbuf_leaf_14_clk clkbuf_4_5_0_clk/X _4950_/CLK VDD VSS sg13g2_buf_8
X_4703_ fanout306/X VSS VDD _4703_/D _4703_/Q _4869_/CLK sg13g2_dfrbpq_1
X_2895_ _2895_/A0 _3103_/A0 _2896_/S _2895_/X VDD VSS sg13g2_mux2_1
X_4634_ fanout252/X VSS VDD _4634_/D _4634_/Q clkload3/A sg13g2_dfrbpq_1
Xhold601 _4866_/Q VDD VSS _2787_/A sg13g2_dlygate4sd3_1
Xhold612 _3141_/Y VDD VSS _4558_/D sg13g2_dlygate4sd3_1
X_4565_ fanout329/X VSS VDD _4565_/D _4565_/Q _4955_/CLK sg13g2_dfrbpq_1
XFILLER_116_554 VDD VSS sg13g2_decap_8
Xhold623 _2574_/X VDD VSS _4889_/D sg13g2_dlygate4sd3_1
Xhold634 _4970_/Q VDD VSS _4170_/B sg13g2_dlygate4sd3_1
Xhold645 _4018_/Y VDD VSS _4955_/D sg13g2_dlygate4sd3_1
X_3516_ _2656_/B _3504_/A _3513_/B _3519_/B VDD VSS sg13g2_a21o_1
XFILLER_116_587 VDD VSS sg13g2_decap_8
XFILLER_116_598 VDD VSS sg13g2_fill_1
Xhold678 _4967_/Q VDD VSS _4139_/B sg13g2_dlygate4sd3_1
Xhold667 _2550_/X VDD VSS _4879_/D sg13g2_dlygate4sd3_1
Xhold656 _3890_/Y VDD VSS _4806_/D sg13g2_dlygate4sd3_1
X_4496_ fanout301/X VSS VDD _4496_/D _4496_/Q _4977_/CLK sg13g2_dfrbpq_1
Xhold689 _2568_/Y VDD VSS _4886_/D sg13g2_dlygate4sd3_1
X_3447_ _3471_/B _3447_/C _3447_/A _3447_/Y VDD VSS sg13g2_nand3_1
XFILLER_100_911 VDD VSS sg13g2_decap_8
XFILLER_58_814 VDD VSS sg13g2_decap_8
XFILLER_69_151 VDD VSS sg13g2_decap_8
X_3378_ _4903_/Q _3378_/B _3378_/C _3424_/C VDD VSS sg13g2_or3_1
XFILLER_85_600 VDD VSS sg13g2_decap_8
Xhold1301 _4857_/Q VDD VSS _3627_/A sg13g2_dlygate4sd3_1
Xhold1312 _3110_/X VDD VSS _4534_/D sg13g2_dlygate4sd3_1
Xhold1323 _4288_/Q VDD VSS _4028_/A1 sg13g2_dlygate4sd3_1
Xhold1334 _3906_/Y VDD VSS _4810_/D sg13g2_dlygate4sd3_1
X_2329_ VDD _2652_/A _2678_/A VSS sg13g2_inv_1
XFILLER_58_869 VDD VSS sg13g2_decap_8
Xhold1345 _4274_/Q VDD VSS _4141_/A0 sg13g2_dlygate4sd3_1
Xhold1356 _4667_/Q VDD VSS _3457_/A sg13g2_dlygate4sd3_1
Xhold1367 _4800_/Q VDD VSS _3871_/A sg13g2_dlygate4sd3_1
XFILLER_85_677 VDD VSS sg13g2_decap_8
XFILLER_66_891 VDD VSS sg13g2_fill_2
XFILLER_84_187 VDD VSS sg13g2_fill_2
Xhold1378 _4733_/Q VDD VSS _3621_/A0 sg13g2_dlygate4sd3_1
Xhold1389 _4737_/Q VDD VSS _3625_/A0 sg13g2_dlygate4sd3_1
XFILLER_85_688 VDD VSS sg13g2_fill_2
XFILLER_25_210 VDD VSS sg13g2_decap_8
Xclkbuf_4_8_0_clk clkbuf_0_clk/X clkbuf_4_8_0_clk/X VDD VSS sg13g2_buf_8
XFILLER_43_79 VDD VSS sg13g2_decap_8
XFILLER_107_543 VDD VSS sg13g2_decap_8
XFILLER_1_810 VDD VSS sg13g2_decap_8
XFILLER_4_169 VDD VSS sg13g2_decap_8
XFILLER_110_719 VDD VSS sg13g2_decap_8
XFILLER_1_887 VDD VSS sg13g2_decap_8
XFILLER_0_375 VDD VSS sg13g2_decap_8
XFILLER_49_836 VDD VSS sg13g2_decap_8
XFILLER_75_121 VDD VSS sg13g2_decap_8
XFILLER_76_633 VDD VSS sg13g2_fill_2
XFILLER_76_644 VDD VSS sg13g2_decap_8
XFILLER_48_357 VDD VSS sg13g2_decap_8
XFILLER_64_817 VDD VSS sg13g2_decap_8
XFILLER_91_603 VDD VSS sg13g2_decap_8
XFILLER_29_582 VDD VSS sg13g2_decap_8
XFILLER_16_232 VDD VSS sg13g2_decap_8
XFILLER_17_755 VDD VSS sg13g2_fill_1
XFILLER_75_198 VDD VSS sg13g2_fill_1
XFILLER_84_75 VDD VSS sg13g2_fill_1
XFILLER_32_758 VDD VSS sg13g2_decap_8
XFILLER_44_596 VDD VSS sg13g2_decap_8
XFILLER_71_393 VDD VSS sg13g2_decap_4
XFILLER_72_894 VDD VSS sg13g2_decap_8
XFILLER_20_909 VDD VSS sg13g2_decap_8
XFILLER_83_7 VDD VSS sg13g2_decap_8
X_2680_ _2330_/A _4708_/Q _4709_/Q _4710_/Q _4711_/Q _2678_/A _2680_/X VDD VSS sg13g2_mux4_1
X_4350_ _4350_/RESET_B VSS VDD _4350_/D _4350_/Q _4966_/CLK sg13g2_dfrbpq_1
X_3301_ _3435_/A _3623_/A1 _3369_/S _4630_/D VDD VSS sg13g2_mux2_1
XFILLER_98_213 VDD VSS sg13g2_decap_4
X_4281_ _4281_/RESET_B VSS VDD _4281_/D _4281_/Q _4976_/CLK sg13g2_dfrbpq_1
XFILLER_99_758 VDD VSS sg13g2_decap_4
Xclkbuf_leaf_3_clk clkbuf_4_1_0_clk/X clkload4/A VDD VSS sg13g2_buf_8
X_3232_ _3232_/A _3232_/B _3232_/Y VDD VSS sg13g2_nor2_1
XFILLER_39_302 VDD VSS sg13g2_decap_4
X_3163_ _3182_/A _3163_/B _4568_/D VDD VSS sg13g2_nor2_1
XFILLER_67_666 VDD VSS sg13g2_decap_4
XFILLER_39_379 VDD VSS sg13g2_decap_8
XFILLER_54_327 VDD VSS sg13g2_decap_8
X_3094_ _3094_/A0 _3119_/A1 _4856_/D _4518_/D VDD VSS sg13g2_mux2_1
XFILLER_94_474 VDD VSS sg13g2_decap_8
XFILLER_81_135 VDD VSS sg13g2_decap_8
XFILLER_35_563 VDD VSS sg13g2_decap_8
XFILLER_62_360 VDD VSS sg13g2_decap_8
XFILLER_22_213 VDD VSS sg13g2_decap_8
XFILLER_23_747 VDD VSS sg13g2_decap_8
XFILLER_50_511 VDD VSS sg13g2_decap_8
Xfanout28 _3766_/A1 _3786_/B VDD VSS sg13g2_buf_1
Xfanout39 _3954_/C _3930_/A VDD VSS sg13g2_buf_1
X_3996_ VSS VDD _3999_/A _4001_/A _3996_/Y _3995_/Y sg13g2_a21oi_1
XFILLER_50_588 VDD VSS sg13g2_decap_8
XFILLER_50_599 VDD VSS sg13g2_fill_2
X_2947_ _4175_/A0 _3026_/A1 _2954_/S _2947_/X VDD VSS sg13g2_mux2_1
X_4617_ fanout281/X VSS VDD _4617_/D _4617_/Q _4946_/CLK sg13g2_dfrbpq_1
X_2878_ _2878_/A0 _3086_/A0 _2902_/S _4311_/D VDD VSS sg13g2_mux2_1
XFILLER_116_373 VDD VSS sg13g2_decap_8
X_4548_ fanout264/X VSS VDD _4548_/D _4548_/Q _4926_/CLK sg13g2_dfrbpq_1
XFILLER_1_128 VDD VSS sg13g2_decap_8
X_4479_ fanout308/X VSS VDD _4479_/D _4479_/Q _4978_/CLK sg13g2_dfrbpq_1
XFILLER_89_279 VDD VSS sg13g2_decap_8
XFILLER_38_35 VDD VSS sg13g2_decap_8
XFILLER_58_622 VDD VSS sg13g2_decap_8
Xhold1120 _2918_/X VDD VSS _4350_/D sg13g2_dlygate4sd3_1
Xhold1131 _2979_/X VDD VSS _4408_/D sg13g2_dlygate4sd3_1
Xhold1142 _4265_/Q VDD VSS _2828_/A0 sg13g2_dlygate4sd3_1
Xhold1153 _4290_/Q VDD VSS _2855_/A0 sg13g2_dlygate4sd3_1
Xhold1164 _4437_/Q VDD VSS _3011_/A0 sg13g2_dlygate4sd3_1
Xhold1175 _3222_/Y VDD VSS _3223_/B sg13g2_dlygate4sd3_1
XFILLER_85_485 VDD VSS sg13g2_decap_8
XFILLER_38_390 VDD VSS sg13g2_decap_8
Xhold1186 _4316_/Q VDD VSS _2883_/A0 sg13g2_dlygate4sd3_1
Xhold1197 _4389_/Q VDD VSS _2960_/A0 sg13g2_dlygate4sd3_1
XFILLER_54_56 VDD VSS sg13g2_fill_1
XFILLER_14_725 VDD VSS sg13g2_decap_8
XFILLER_81_691 VDD VSS sg13g2_decap_8
XFILLER_110_84 VDD VSS sg13g2_decap_8
XFILLER_41_599 VDD VSS sg13g2_fill_1
XFILLER_9_228 VDD VSS sg13g2_decap_8
XFILLER_6_924 VDD VSS sg13g2_fill_2
XFILLER_5_423 VDD VSS sg13g2_decap_8
XFILLER_107_373 VDD VSS sg13g2_fill_2
XFILLER_5_478 VDD VSS sg13g2_decap_8
XFILLER_107_384 VDD VSS sg13g2_fill_2
XFILLER_0_161 VDD VSS sg13g2_decap_8
XFILLER_49_622 VDD VSS sg13g2_decap_8
XFILLER_49_655 VDD VSS sg13g2_fill_2
XFILLER_49_666 VDD VSS sg13g2_decap_8
XFILLER_92_901 VDD VSS sg13g2_decap_8
XFILLER_76_485 VDD VSS sg13g2_decap_8
XFILLER_64_658 VDD VSS sg13g2_decap_8
XFILLER_91_422 VDD VSS sg13g2_decap_8
XFILLER_32_500 VDD VSS sg13g2_decap_8
XFILLER_32_555 VDD VSS sg13g2_decap_8
XFILLER_60_864 VDD VSS sg13g2_decap_8
X_3850_ _3850_/Y _3850_/A _3850_/B VDD VSS sg13g2_nand2_1
X_3781_ _3778_/Y VDD _3781_/Y VSS _3786_/B _3780_/Y sg13g2_o21ai_1
X_2801_ _2807_/A _2801_/B _2801_/C _4909_/D VDD VSS sg13g2_nor3_1
X_2732_ _2733_/A _2733_/B _2739_/C VDD VSS sg13g2_and2_1
XFILLER_9_762 VDD VSS sg13g2_decap_8
X_2663_ VSS VDD _2661_/Y _2662_/Y _2663_/Y _3511_/A sg13g2_a21oi_1
XFILLER_8_294 VDD VSS sg13g2_decap_8
X_4402_ _4402_/RESET_B VSS VDD _4402_/D _4402_/Q _4958_/CLK sg13g2_dfrbpq_1
X_2594_ _4588_/Q _4589_/Q _3213_/A _3208_/B _3215_/B VDD VSS sg13g2_nor4_1
XFILLER_5_50 VDD VSS sg13g2_decap_8
X_4333_ _4333_/RESET_B VSS VDD _4333_/D _4333_/Q _4397_/CLK sg13g2_dfrbpq_1
XFILLER_99_544 VDD VSS sg13g2_decap_8
XFILLER_114_877 VDD VSS sg13g2_fill_2
Xfanout207 hold1641/X _3718_/A VDD VSS sg13g2_buf_1
Xfanout218 hold1673/X _3493_/A VDD VSS sg13g2_buf_1
Xfanout229 _4526_/Q _3026_/A1 VDD VSS sg13g2_buf_1
X_4264_ _4264_/RESET_B VSS VDD _4264_/D _4264_/Q _4658_/CLK sg13g2_dfrbpq_1
XFILLER_113_376 VDD VSS sg13g2_decap_8
X_3215_ _3215_/Y _3215_/A _3215_/B VDD VSS sg13g2_xnor2_1
XFILLER_28_806 VDD VSS sg13g2_decap_8
X_4195_ _4197_/S _4429_/Q _4195_/Y VDD VSS sg13g2_nor2_1
XFILLER_95_750 VDD VSS sg13g2_decap_4
XFILLER_39_165 VDD VSS sg13g2_decap_8
X_3146_ _3145_/B VDD _3146_/Y VSS _3147_/A _3144_/A sg13g2_o21ai_1
XFILLER_43_809 VDD VSS sg13g2_decap_8
X_3077_ _4179_/B hold808/X _3084_/S _4501_/D VDD VSS sg13g2_mux2_1
XFILLER_36_872 VDD VSS sg13g2_decap_8
XFILLER_42_319 VDD VSS sg13g2_decap_8
XFILLER_82_477 VDD VSS sg13g2_decap_8
XFILLER_51_831 VDD VSS sg13g2_fill_2
XFILLER_63_680 VDD VSS sg13g2_decap_8
XFILLER_24_26 VDD VSS sg13g2_decap_4
XFILLER_10_238 VDD VSS sg13g2_decap_8
X_3979_ _3999_/A _3979_/B _3979_/Y VDD VSS sg13g2_nor2_1
XFILLER_109_627 VDD VSS sg13g2_decap_8
XFILLER_3_905 VDD VSS sg13g2_decap_8
XFILLER_2_415 VDD VSS sg13g2_decap_8
XFILLER_104_365 VDD VSS sg13g2_decap_8
XFILLER_105_877 VDD VSS sg13g2_decap_4
XFILLER_78_706 VDD VSS sg13g2_fill_1
XFILLER_49_56 VDD VSS sg13g2_decap_8
XFILLER_59_920 VDD VSS sg13g2_decap_4
XFILLER_19_806 VDD VSS sg13g2_fill_2
XFILLER_58_441 VDD VSS sg13g2_decap_4
XFILLER_105_84 VDD VSS sg13g2_fill_1
XFILLER_92_208 VDD VSS sg13g2_fill_1
XFILLER_100_582 VDD VSS sg13g2_fill_1
XFILLER_18_349 VDD VSS sg13g2_decap_8
XFILLER_73_433 VDD VSS sg13g2_decap_8
XFILLER_45_168 VDD VSS sg13g2_decap_8
XFILLER_61_617 VDD VSS sg13g2_fill_2
XFILLER_65_77 VDD VSS sg13g2_decap_8
XFILLER_26_360 VDD VSS sg13g2_decap_8
XFILLER_60_116 VDD VSS sg13g2_decap_8
XFILLER_14_544 VDD VSS sg13g2_decap_8
XFILLER_41_341 VDD VSS sg13g2_decap_8
XFILLER_42_864 VDD VSS sg13g2_decap_8
XFILLER_14_92 VDD VSS sg13g2_decap_4
XFILLER_6_721 VDD VSS sg13g2_decap_8
XFILLER_115_619 VDD VSS sg13g2_fill_2
XFILLER_107_181 VDD VSS sg13g2_decap_8
XFILLER_46_7 VDD VSS sg13g2_decap_8
XFILLER_6_798 VDD VSS sg13g2_decap_8
XFILLER_111_814 VDD VSS sg13g2_decap_8
XFILLER_69_739 VDD VSS sg13g2_decap_8
XFILLER_37_625 VDD VSS sg13g2_decap_8
XFILLER_77_783 VDD VSS sg13g2_decap_8
Xinput7 slot_sel[2] input7/X VDD VSS sg13g2_buf_1
X_3000_ _4173_/B _3026_/A1 _3003_/S _3000_/X VDD VSS sg13g2_mux2_1
XFILLER_36_113 VDD VSS sg13g2_decap_8
XFILLER_64_422 VDD VSS sg13g2_decap_8
XFILLER_36_157 VDD VSS sg13g2_decap_8
XFILLER_36_168 VDD VSS sg13g2_decap_4
X_4951_ fanout275/X VSS VDD _4951_/D _4951_/Q _4954_/CLK sg13g2_dfrbpq_1
X_4882_ fanout303/X VSS VDD _4882_/D _4882_/Q _4884_/CLK sg13g2_dfrbpq_1
X_3902_ _4809_/Q _3902_/C _3905_/A _3907_/C VDD VSS _3905_/D sg13g2_nand4_1
X_3833_ _3848_/A VDD _3833_/Y VSS _3835_/B _3832_/X sg13g2_o21ai_1
XFILLER_72_0 VDD VSS sg13g2_decap_8
X_3764_ _3800_/A _3832_/A _3764_/C _3764_/D _3770_/C VDD VSS sg13g2_and4_1
X_3695_ _3695_/Y _4736_/Q _3694_/A VDD VSS sg13g2_nand2b_1
X_2715_ _4867_/Q _2787_/C _2790_/A _2715_/Y VDD VSS sg13g2_nor3_1
XFILLER_9_592 VDD VSS sg13g2_decap_8
XFILLER_106_608 VDD VSS sg13g2_decap_8
X_2646_ VDD VSS _3640_/B _3654_/S _3691_/A _2646_/A1 _2646_/Y _4840_/Q sg13g2_a221oi_1
XFILLER_102_803 VDD VSS sg13g2_decap_8
X_2577_ _2577_/A _2583_/D _4890_/D VDD VSS sg13g2_nor2_1
XFILLER_101_302 VDD VSS sg13g2_fill_1
XFILLER_59_205 VDD VSS sg13g2_decap_8
X_4316_ _4316_/RESET_B VSS VDD _4316_/D _4316_/Q clkload5/A sg13g2_dfrbpq_1
XFILLER_99_374 VDD VSS sg13g2_decap_8
X_4247_ _4246_/Y VDD _4247_/Y VSS _4244_/Y _4245_/Y sg13g2_o21ai_1
XFILLER_87_547 VDD VSS sg13g2_decap_8
XFILLER_101_379 VDD VSS sg13g2_decap_8
XFILLER_55_400 VDD VSS sg13g2_decap_8
XFILLER_68_772 VDD VSS sg13g2_decap_8
XFILLER_68_783 VDD VSS sg13g2_fill_1
XFILLER_74_208 VDD VSS sg13g2_decap_8
X_4178_ _4227_/B1 VDD _4178_/Y VSS _4227_/A1 _4178_/A2 sg13g2_o21ai_1
XFILLER_67_293 VDD VSS sg13g2_decap_8
XFILLER_83_731 VDD VSS sg13g2_decap_8
XFILLER_95_580 VDD VSS sg13g2_fill_1
XFILLER_27_146 VDD VSS sg13g2_fill_2
XFILLER_28_669 VDD VSS sg13g2_decap_8
XFILLER_55_455 VDD VSS sg13g2_decap_8
X_3129_ _3128_/Y VDD _3129_/Y VSS _4625_/Q _3128_/B sg13g2_o21ai_1
XFILLER_27_179 VDD VSS sg13g2_decap_8
XFILLER_35_36 VDD VSS sg13g2_fill_1
XFILLER_70_458 VDD VSS sg13g2_fill_2
XFILLER_23_363 VDD VSS sg13g2_fill_1
XFILLER_51_661 VDD VSS sg13g2_decap_8
XFILLER_51_24 VDD VSS sg13g2_fill_2
XFILLER_51_57 VDD VSS sg13g2_decap_4
XFILLER_109_468 VDD VSS sg13g2_decap_8
XFILLER_3_702 VDD VSS sg13g2_decap_8
XFILLER_3_779 VDD VSS sg13g2_decap_8
XFILLER_2_267 VDD VSS sg13g2_fill_1
XFILLER_78_547 VDD VSS sg13g2_decap_8
XFILLER_59_783 VDD VSS sg13g2_decap_8
XFILLER_76_54 VDD VSS sg13g2_fill_2
XFILLER_19_647 VDD VSS sg13g2_decap_4
XFILLER_74_720 VDD VSS sg13g2_decap_8
XFILLER_93_539 VDD VSS sg13g2_decap_8
XFILLER_62_904 VDD VSS sg13g2_decap_8
XFILLER_74_753 VDD VSS sg13g2_decap_8
XFILLER_15_831 VDD VSS sg13g2_decap_4
XFILLER_92_42 VDD VSS sg13g2_decap_8
XFILLER_33_149 VDD VSS sg13g2_decap_8
XFILLER_30_801 VDD VSS sg13g2_decap_8
X_4299__427 VDD VSS _4299_/RESET_B sg13g2_tiehi
X_3480_ _3479_/Y VDD _3480_/Y VSS _2281_/Y _3477_/C sg13g2_o21ai_1
X_2500_ _4257_/A _2501_/A _4899_/D VDD VSS sg13g2_nor2b_1
X_2431_ _2792_/B _2431_/C _2431_/A _2431_/Y VDD VSS _2431_/D sg13g2_nand4_1
XFILLER_97_801 VDD VSS sg13g2_decap_4
XFILLER_69_503 VDD VSS sg13g2_decap_8
X_2362_ _2362_/Y _4662_/Q _4654_/Q VDD VSS sg13g2_nand2_1
X_4101_ _4100_/Y VDD _4101_/Y VSS _4121_/A _2352_/Y sg13g2_o21ai_1
X_2293_ VDD _3835_/A _3800_/A VSS sg13g2_inv_1
XFILLER_97_878 VDD VSS sg13g2_decap_8
XFILLER_84_506 VDD VSS sg13g2_decap_8
X_4032_ _4227_/A1 VDD _4032_/Y VSS _4029_/Y _4030_/Y sg13g2_o21ai_1
XFILLER_96_377 VDD VSS sg13g2_decap_8
XFILLER_49_282 VDD VSS sg13g2_decap_4
XFILLER_65_731 VDD VSS sg13g2_decap_8
XFILLER_53_904 VDD VSS sg13g2_decap_8
XFILLER_80_723 VDD VSS sg13g2_decap_8
XFILLER_92_594 VDD VSS sg13g2_decap_8
XFILLER_18_691 VDD VSS sg13g2_decap_8
XFILLER_24_138 VDD VSS sg13g2_decap_8
X_4934_ fanout333/X VSS VDD _4934_/D _4934_/Q _4941_/CLK sg13g2_dfrbpq_1
XFILLER_21_812 VDD VSS sg13g2_decap_8
XFILLER_20_300 VDD VSS sg13g2_decap_8
XFILLER_32_182 VDD VSS sg13g2_decap_8
X_4865_ fanout326/X VSS VDD _4865_/D _4865_/Q _4870_/CLK sg13g2_dfrbpq_1
XFILLER_21_878 VDD VSS sg13g2_decap_8
X_4796_ fanout315/X VSS VDD _4796_/D _4796_/Q _4931_/CLK sg13g2_dfrbpq_1
X_3816_ _3816_/Y _3807_/Y _3815_/Y _3837_/A2 _2325_/Y VDD VSS sg13g2_a22oi_1
X_3747_ _3746_/X VDD _3747_/Y VSS _3820_/A _2757_/Y sg13g2_o21ai_1
XFILLER_106_427 VDD VSS sg13g2_fill_2
XFILLER_108_9 VDD VSS sg13g2_fill_1
X_3678_ hold614/X VDD _3678_/Y VSS _3677_/B _3676_/Y sg13g2_o21ai_1
X_2629_ _4830_/Q _4828_/Q _3977_/S _2629_/Y VDD VSS _4829_/Q sg13g2_nand4_1
XFILLER_88_801 VDD VSS sg13g2_decap_8
XFILLER_101_110 VDD VSS sg13g2_decap_8
XFILLER_99_182 VDD VSS sg13g2_decap_8
XFILLER_88_856 VDD VSS sg13g2_decap_8
XFILLER_101_165 VDD VSS sg13g2_decap_8
XFILLER_28_455 VDD VSS sg13g2_decap_8
XFILLER_46_46 VDD VSS sg13g2_decap_8
XFILLER_55_241 VDD VSS sg13g2_fill_2
XFILLER_56_775 VDD VSS sg13g2_decap_8
XFILLER_15_116 VDD VSS sg13g2_decap_8
XFILLER_16_639 VDD VSS sg13g2_decap_4
XFILLER_43_403 VDD VSS sg13g2_decap_8
XFILLER_55_274 VDD VSS sg13g2_decap_8
XFILLER_56_786 VDD VSS sg13g2_fill_2
XFILLER_102_63 VDD VSS sg13g2_decap_8
XFILLER_43_447 VDD VSS sg13g2_fill_1
XFILLER_24_650 VDD VSS sg13g2_fill_1
XFILLER_70_277 VDD VSS sg13g2_fill_2
XFILLER_12_867 VDD VSS sg13g2_decap_8
XFILLER_2_0 VDD VSS sg13g2_decap_8
XFILLER_79_812 VDD VSS sg13g2_decap_8
XFILLER_87_53 VDD VSS sg13g2_decap_8
XFILLER_59_580 VDD VSS sg13g2_fill_1
XFILLER_47_775 VDD VSS sg13g2_decap_4
XFILLER_34_425 VDD VSS sg13g2_fill_1
XFILLER_61_200 VDD VSS sg13g2_decap_8
XFILLER_15_661 VDD VSS sg13g2_fill_1
XFILLER_15_672 VDD VSS sg13g2_fill_2
XFILLER_61_266 VDD VSS sg13g2_decap_8
X_2980_ _2980_/A0 _3109_/A0 _2980_/S _4409_/D VDD VSS sg13g2_mux2_1
XFILLER_14_182 VDD VSS sg13g2_decap_8
XFILLER_42_491 VDD VSS sg13g2_decap_8
X_4650_ fanout264/X VSS VDD _4650_/D _4650_/Q _4926_/CLK sg13g2_dfrbpq_1
X_3601_ _3601_/Y _3604_/A _3601_/B VDD VSS sg13g2_nand2_1
X_4581_ fanout288/X VSS VDD _4581_/D _4581_/Q _4601_/CLK sg13g2_dfrbpq_1
XFILLER_116_747 VDD VSS sg13g2_decap_8
XFILLER_7_893 VDD VSS sg13g2_decap_8
Xhold827 _2888_/X VDD VSS _4321_/D sg13g2_dlygate4sd3_1
Xhold816 _3723_/Y VDD VSS _4755_/D sg13g2_dlygate4sd3_1
Xhold805 _3450_/Y VDD VSS _4662_/D sg13g2_dlygate4sd3_1
X_3532_ _3532_/A0 _3532_/A1 _3552_/S _4694_/D VDD VSS sg13g2_mux2_1
XFILLER_115_257 VDD VSS sg13g2_decap_8
Xhold849 _4464_/Q VDD VSS hold849/X sg13g2_dlygate4sd3_1
Xhold838 _4797_/Q VDD VSS hold838/X sg13g2_dlygate4sd3_1
X_3463_ _3483_/B _3481_/C _3463_/A _3463_/Y VDD VSS sg13g2_nand3_1
XFILLER_103_408 VDD VSS sg13g2_decap_8
X_2414_ _2414_/B _2414_/C _2792_/A _2429_/B VDD VSS _2798_/A sg13g2_nand4_1
XFILLER_111_430 VDD VSS sg13g2_fill_2
X_3394_ _3394_/A _3307_/B _3395_/B VDD VSS sg13g2_nor2b_1
XFILLER_69_355 VDD VSS sg13g2_decap_8
Xhold1505 _2440_/Y VDD VSS _4914_/D sg13g2_dlygate4sd3_1
Xhold1516 _3208_/X VDD VSS _3209_/B sg13g2_dlygate4sd3_1
X_2345_ VDD _3995_/B _2345_/A VSS sg13g2_inv_1
XFILLER_29_219 VDD VSS sg13g2_decap_8
XFILLER_38_720 VDD VSS sg13g2_fill_1
Xhold1527 _2711_/Y VDD VSS _4861_/D sg13g2_dlygate4sd3_1
Xhold1538 _4761_/Q VDD VSS _3743_/A sg13g2_dlygate4sd3_1
Xhold1549 _3162_/Y VDD VSS _3163_/B sg13g2_dlygate4sd3_1
X_2276_ VDD _2276_/Y _4658_/Q VSS sg13g2_inv_1
XFILLER_96_185 VDD VSS sg13g2_decap_8
XFILLER_72_509 VDD VSS sg13g2_decap_8
X_4015_ VSS VDD _4199_/A1 _4013_/X _4015_/Y _4014_/Y sg13g2_a21oi_1
XFILLER_25_414 VDD VSS sg13g2_fill_2
XFILLER_38_786 VDD VSS sg13g2_fill_2
XFILLER_80_520 VDD VSS sg13g2_decap_8
XFILLER_12_108 VDD VSS sg13g2_decap_8
XFILLER_52_255 VDD VSS sg13g2_decap_8
XFILLER_52_266 VDD VSS sg13g2_fill_2
XFILLER_80_586 VDD VSS sg13g2_decap_4
X_4917_ fanout261/X VSS VDD _4917_/D _4917_/Q clkload6/A sg13g2_dfrbpq_1
XFILLER_21_642 VDD VSS sg13g2_decap_8
X_4848_ _2849_/C VSS VDD _4848_/D _4848_/Q _4931_/CLK sg13g2_dfrbpq_1
X_4779_ fanout259/X VSS VDD _4779_/D _4779_/Q clkload0/A sg13g2_dfrbpq_1
XFILLER_106_224 VDD VSS sg13g2_decap_8
XFILLER_107_747 VDD VSS sg13g2_decap_8
XFILLER_113_7 VDD VSS sg13g2_decap_8
XFILLER_106_235 VDD VSS sg13g2_fill_1
XFILLER_102_430 VDD VSS sg13g2_decap_8
XFILLER_0_557 VDD VSS sg13g2_decap_8
XFILLER_48_517 VDD VSS sg13g2_decap_8
XFILLER_87_152 VDD VSS sg13g2_decap_8
XFILLER_75_314 VDD VSS sg13g2_decap_8
XFILLER_88_697 VDD VSS sg13g2_decap_8
XFILLER_57_89 VDD VSS sg13g2_decap_8
XFILLER_16_403 VDD VSS sg13g2_decap_8
XFILLER_44_701 VDD VSS sg13g2_fill_1
XFILLER_44_712 VDD VSS sg13g2_decap_8
XFILLER_90_328 VDD VSS sg13g2_decap_8
XFILLER_16_447 VDD VSS sg13g2_fill_2
XFILLER_43_222 VDD VSS sg13g2_decap_8
X_4289__437 VDD VSS _4289_/RESET_B sg13g2_tiehi
XFILLER_73_77 VDD VSS sg13g2_decap_8
XFILLER_73_99 VDD VSS sg13g2_decap_8
XFILLER_7_156 VDD VSS sg13g2_decap_8
XFILLER_22_81 VDD VSS sg13g2_decap_8
XFILLER_7_167 VDD VSS sg13g2_fill_2
XFILLER_4_830 VDD VSS sg13g2_decap_8
XFILLER_3_340 VDD VSS sg13g2_fill_1
XFILLER_3_362 VDD VSS sg13g2_decap_4
XFILLER_98_63 VDD VSS sg13g2_fill_1
XFILLER_79_653 VDD VSS sg13g2_decap_8
XFILLER_93_122 VDD VSS sg13g2_decap_8
XFILLER_82_807 VDD VSS sg13g2_decap_8
XFILLER_47_572 VDD VSS sg13g2_fill_2
XFILLER_75_870 VDD VSS sg13g2_decap_4
XFILLER_19_285 VDD VSS sg13g2_decap_8
XFILLER_35_734 VDD VSS sg13g2_decap_8
XFILLER_93_199 VDD VSS sg13g2_decap_8
XFILLER_50_715 VDD VSS sg13g2_decap_8
XFILLER_90_873 VDD VSS sg13g2_decap_8
XFILLER_15_480 VDD VSS sg13g2_fill_1
XFILLER_62_597 VDD VSS sg13g2_decap_8
X_2963_ hold992/X _3092_/A0 _2981_/S _4392_/D VDD VSS sg13g2_mux2_1
X_4702_ fanout308/X VSS VDD _4702_/D _4702_/Q _4978_/CLK sg13g2_dfrbpq_1
X_2894_ _2894_/A0 _3026_/A1 _2901_/S _2894_/X VDD VSS sg13g2_mux2_1
X_4633_ fanout252/X VSS VDD _4633_/D _4633_/Q clkload3/A sg13g2_dfrbpq_1
Xhold602 _4756_/Q VDD VSS _3726_/A sg13g2_dlygate4sd3_1
X_4564_ fanout329/X VSS VDD _4564_/D _4564_/Q _4955_/CLK sg13g2_dfrbpq_1
XFILLER_116_533 VDD VSS sg13g2_decap_8
Xhold613 _4750_/Q VDD VSS _3677_/A sg13g2_dlygate4sd3_1
Xhold624 _4881_/Q VDD VSS _2556_/A sg13g2_dlygate4sd3_1
Xhold635 _4171_/Y VDD VSS _4970_/D sg13g2_dlygate4sd3_1
X_3515_ _3513_/Y VDD _3515_/Y VSS _3504_/Y _3514_/Y sg13g2_o21ai_1
XFILLER_104_717 VDD VSS sg13g2_fill_1
Xhold679 _4140_/Y VDD VSS _4967_/D sg13g2_dlygate4sd3_1
Xhold668 _4636_/Q VDD VSS _3357_/A sg13g2_dlygate4sd3_1
Xhold657 _4890_/Q VDD VSS _2576_/B sg13g2_dlygate4sd3_1
Xhold646 _4974_/Q VDD VSS _4210_/B sg13g2_dlygate4sd3_1
X_4495_ fanout312/X VSS VDD _4495_/D _4495_/Q _4527_/CLK sg13g2_dfrbpq_1
X_4394__532 VDD VSS _4394_/RESET_B sg13g2_tiehi
X_3446_ _3445_/Y VDD _3446_/Y VSS _2263_/Y _3447_/C sg13g2_o21ai_1
XFILLER_89_439 VDD VSS sg13g2_decap_8
XFILLER_69_130 VDD VSS sg13g2_decap_8
X_3377_ _3377_/Y _3376_/Y _3360_/Y _3495_/A _3424_/B VDD VSS sg13g2_a22oi_1
XFILLER_111_282 VDD VSS sg13g2_fill_1
XFILLER_84_111 VDD VSS sg13g2_decap_8
Xhold1302 _4492_/Q VDD VSS _3066_/A1 sg13g2_dlygate4sd3_1
Xhold1313 _4659_/Q VDD VSS _3441_/A sg13g2_dlygate4sd3_1
Xhold1324 _4028_/X VDD VSS _4034_/A2 sg13g2_dlygate4sd3_1
X_2328_ VDD _3424_/B _2328_/A VSS sg13g2_inv_1
XFILLER_97_483 VDD VSS sg13g2_decap_8
Xhold1335 _4540_/Q VDD VSS _3116_/A1 sg13g2_dlygate4sd3_1
Xhold1346 _4855_/Q VDD VSS _2488_/A sg13g2_dlygate4sd3_1
Xhold1357 _4946_/Q VDD VSS _2730_/D sg13g2_dlygate4sd3_1
Xhold1368 _4611_/Q VDD VSS _3263_/A sg13g2_dlygate4sd3_1
XFILLER_85_656 VDD VSS sg13g2_decap_8
XFILLER_84_166 VDD VSS sg13g2_decap_8
Xhold1379 _3621_/X VDD VSS _4733_/D sg13g2_dlygate4sd3_1
X_2259_ VDD _2508_/C _2259_/A VSS sg13g2_inv_1
XFILLER_26_745 VDD VSS sg13g2_fill_2
XFILLER_53_542 VDD VSS sg13g2_fill_1
XFILLER_14_907 VDD VSS sg13g2_decap_8
XFILLER_26_789 VDD VSS sg13g2_decap_4
XFILLER_43_14 VDD VSS sg13g2_decap_8
XFILLER_13_428 VDD VSS sg13g2_decap_4
XFILLER_43_58 VDD VSS sg13g2_decap_8
XFILLER_21_483 VDD VSS sg13g2_decap_4
XFILLER_108_51 VDD VSS sg13g2_decap_4
XFILLER_4_159 VDD VSS sg13g2_fill_1
XFILLER_107_599 VDD VSS sg13g2_decap_8
XFILLER_108_84 VDD VSS sg13g2_decap_4
XFILLER_0_354 VDD VSS sg13g2_decap_8
XFILLER_1_866 VDD VSS sg13g2_decap_8
XFILLER_49_815 VDD VSS sg13g2_decap_8
XFILLER_48_314 VDD VSS sg13g2_fill_2
XFILLER_68_88 VDD VSS sg13g2_decap_8
XFILLER_88_483 VDD VSS sg13g2_decap_8
XFILLER_17_701 VDD VSS sg13g2_fill_1
XFILLER_75_177 VDD VSS sg13g2_decap_8
XFILLER_84_54 VDD VSS sg13g2_decap_8
XFILLER_16_211 VDD VSS sg13g2_decap_8
XFILLER_72_840 VDD VSS sg13g2_decap_8
XFILLER_91_659 VDD VSS sg13g2_decap_8
XFILLER_90_147 VDD VSS sg13g2_fill_2
XFILLER_90_125 VDD VSS sg13g2_decap_8
XFILLER_17_92 VDD VSS sg13g2_decap_8
XFILLER_44_575 VDD VSS sg13g2_decap_8
XFILLER_72_873 VDD VSS sg13g2_decap_8
XFILLER_90_169 VDD VSS sg13g2_decap_8
XFILLER_90_158 VDD VSS sg13g2_fill_2
XFILLER_16_299 VDD VSS sg13g2_decap_4
XFILLER_71_372 VDD VSS sg13g2_decap_8
XFILLER_12_461 VDD VSS sg13g2_decap_8
XFILLER_76_7 VDD VSS sg13g2_decap_8
XFILLER_99_704 VDD VSS sg13g2_decap_4
XFILLER_113_503 VDD VSS sg13g2_fill_2
X_3300_ _3433_/A _3300_/A1 _3369_/S _4629_/D VDD VSS sg13g2_mux2_1
XFILLER_113_547 VDD VSS sg13g2_decap_8
XFILLER_3_181 VDD VSS sg13g2_decap_8
X_4280_ _4280_/RESET_B VSS VDD _4280_/D _4280_/Q _4971_/CLK sg13g2_dfrbpq_1
XFILLER_113_558 VDD VSS sg13g2_fill_2
XFILLER_67_601 VDD VSS sg13g2_decap_8
X_3231_ _2599_/B VDD _3231_/Y VSS _4597_/Q _3229_/B sg13g2_o21ai_1
X_3162_ _3162_/Y _3162_/A _3162_/B VDD VSS sg13g2_xnor2_1
XFILLER_95_921 VDD VSS sg13g2_decap_4
XFILLER_67_645 VDD VSS sg13g2_decap_8
XFILLER_54_306 VDD VSS sg13g2_decap_8
XFILLER_66_177 VDD VSS sg13g2_decap_4
XFILLER_82_604 VDD VSS sg13g2_decap_8
XFILLER_82_615 VDD VSS sg13g2_fill_2
X_3093_ hold792/X _4542_/Q _3108_/S _3093_/X VDD VSS sg13g2_mux2_1
XFILLER_47_380 VDD VSS sg13g2_decap_8
XFILLER_48_892 VDD VSS sg13g2_decap_8
XFILLER_81_125 VDD VSS sg13g2_decap_4
XFILLER_82_659 VDD VSS sg13g2_decap_8
XFILLER_63_884 VDD VSS sg13g2_decap_8
XFILLER_81_158 VDD VSS sg13g2_fill_1
Xfanout29 _3753_/A _3766_/A1 VDD VSS sg13g2_buf_1
XFILLER_50_567 VDD VSS sg13g2_decap_8
X_3995_ _3999_/A _3995_/B _3995_/Y VDD VSS sg13g2_nor2_1
XFILLER_10_409 VDD VSS sg13g2_decap_8
XFILLER_22_269 VDD VSS sg13g2_decap_8
X_2946_ _2946_/A0 _3101_/A0 _2949_/S _4376_/D VDD VSS sg13g2_mux2_1
X_2877_ _2983_/A _2903_/B _2877_/Y VDD VSS sg13g2_nor2_1
X_4616_ fanout282/X VSS VDD _4616_/D _4616_/Q _4619_/CLK sg13g2_dfrbpq_1
XFILLER_104_514 VDD VSS sg13g2_fill_1
XFILLER_116_352 VDD VSS sg13g2_fill_2
XFILLER_1_107 VDD VSS sg13g2_decap_8
XFILLER_2_608 VDD VSS sg13g2_decap_8
XFILLER_2_619 VDD VSS sg13g2_fill_1
X_4547_ fanout299/X VSS VDD _4547_/D _4547_/Q _4976_/CLK sg13g2_dfrbpq_1
X_4478_ fanout323/X VSS VDD _4478_/D _4478_/Q _4729_/CLK sg13g2_dfrbpq_1
X_4279__447 VDD VSS _4279_/RESET_B sg13g2_tiehi
XFILLER_104_558 VDD VSS sg13g2_decap_8
XFILLER_58_601 VDD VSS sg13g2_decap_8
X_3429_ _3453_/B _3471_/C _3429_/A _3429_/Y VDD VSS sg13g2_nand3_1
XFILLER_89_258 VDD VSS sg13g2_decap_8
XFILLER_112_580 VDD VSS sg13g2_decap_8
XFILLER_38_14 VDD VSS sg13g2_decap_8
XFILLER_86_921 VDD VSS sg13g2_decap_4
XFILLER_57_133 VDD VSS sg13g2_decap_8
Xhold1110 _2926_/X VDD VSS _4358_/D sg13g2_dlygate4sd3_1
Xhold1121 _4446_/Q VDD VSS _3020_/A0 sg13g2_dlygate4sd3_1
Xhold1132 _4287_/Q VDD VSS _2852_/A0 sg13g2_dlygate4sd3_1
Xhold1143 _2828_/X VDD VSS _4265_/D sg13g2_dlygate4sd3_1
Xhold1154 _2855_/X VDD VSS _4290_/D sg13g2_dlygate4sd3_1
Xhold1165 _4396_/Q VDD VSS _2967_/A0 sg13g2_dlygate4sd3_1
Xhold1176 _4288_/Q VDD VSS _2853_/A0 sg13g2_dlygate4sd3_1
XFILLER_85_464 VDD VSS sg13g2_decap_8
XFILLER_73_659 VDD VSS sg13g2_decap_8
Xhold1187 _2883_/X VDD VSS _4316_/D sg13g2_dlygate4sd3_1
Xhold1198 _2960_/X VDD VSS _4389_/D sg13g2_dlygate4sd3_1
XFILLER_14_715 VDD VSS sg13g2_fill_1
XFILLER_54_35 VDD VSS sg13g2_decap_8
XFILLER_72_158 VDD VSS sg13g2_decap_8
XFILLER_53_383 VDD VSS sg13g2_fill_2
XFILLER_110_63 VDD VSS sg13g2_decap_8
XFILLER_6_903 VDD VSS sg13g2_decap_8
XFILLER_102_0 VDD VSS sg13g2_decap_8
XFILLER_79_76 VDD VSS sg13g2_decap_8
XFILLER_0_140 VDD VSS sg13g2_decap_8
XFILLER_77_921 VDD VSS sg13g2_decap_4
XFILLER_48_122 VDD VSS sg13g2_decap_8
XFILLER_76_420 VDD VSS sg13g2_fill_2
XFILLER_95_75 VDD VSS sg13g2_decap_8
XFILLER_88_291 VDD VSS sg13g2_decap_4
XFILLER_37_829 VDD VSS sg13g2_decap_8
XFILLER_48_155 VDD VSS sg13g2_fill_2
XFILLER_64_604 VDD VSS sg13g2_decap_8
XFILLER_48_199 VDD VSS sg13g2_decap_4
XFILLER_64_637 VDD VSS sg13g2_decap_8
XFILLER_45_873 VDD VSS sg13g2_fill_2
XFILLER_63_158 VDD VSS sg13g2_decap_8
XFILLER_20_718 VDD VSS sg13g2_decap_8
XFILLER_60_898 VDD VSS sg13g2_fill_1
X_3780_ _3780_/Y _3786_/C _3777_/Y VDD VSS sg13g2_nand2b_1
X_2800_ _2800_/A _2800_/B _2800_/Y VDD VSS sg13g2_nor2_1
X_2731_ _2749_/A _2731_/B _2733_/B _2731_/Y VDD VSS sg13g2_nor3_1
X_4401_ _4401_/RESET_B VSS VDD _4401_/D _4401_/Q _4972_/CLK sg13g2_dfrbpq_1
X_2662_ VSS VDD _2330_/A _4705_/Q _2662_/Y _2678_/A sg13g2_a21oi_1
X_2593_ _3208_/A _2593_/B _3208_/B _3213_/B VDD VSS sg13g2_nor3_1
XFILLER_114_856 VDD VSS sg13g2_decap_8
X_4332_ _4332_/RESET_B VSS VDD _4332_/D _4332_/Q clkload8/A sg13g2_dfrbpq_1
XFILLER_99_523 VDD VSS sg13g2_decap_8
Xfanout208 _4740_/Q _3706_/A VDD VSS sg13g2_buf_1
Xfanout219 _4647_/Q _3394_/A VDD VSS sg13g2_buf_1
X_4263_ _4263_/RESET_B VSS VDD _4263_/D _4263_/Q _4926_/CLK sg13g2_dfrbpq_1
Xclkbuf_4_7_0_clk clkbuf_0_clk/X clkbuf_4_7_0_clk/X VDD VSS sg13g2_buf_8
X_4391__535 VDD VSS _4391_/RESET_B sg13g2_tiehi
X_3214_ _3230_/A _3214_/B _4590_/D VDD VSS sg13g2_nor2_1
XFILLER_86_239 VDD VSS sg13g2_decap_4
X_4194_ _4197_/S _4279_/Q _4304_/Q _4329_/Q _4354_/Q _4196_/B1 _4194_/X VDD VSS sg13g2_mux4_1
XFILLER_83_924 VDD VSS sg13g2_fill_2
X_3145_ _3182_/A _3145_/B _3144_/A VDD VSS sg13g2_nand2b_1
XFILLER_95_795 VDD VSS sg13g2_fill_1
XFILLER_95_784 VDD VSS sg13g2_decap_8
XFILLER_67_497 VDD VSS sg13g2_decap_8
X_3076_ _4170_/B hold931/X _3085_/S _4500_/D VDD VSS sg13g2_mux2_1
XFILLER_36_851 VDD VSS sg13g2_decap_8
XFILLER_70_618 VDD VSS sg13g2_fill_1
XFILLER_63_670 VDD VSS sg13g2_decap_4
XFILLER_11_707 VDD VSS sg13g2_decap_8
XFILLER_23_556 VDD VSS sg13g2_decap_8
XFILLER_35_394 VDD VSS sg13g2_decap_8
XFILLER_50_342 VDD VSS sg13g2_decap_4
XFILLER_51_865 VDD VSS sg13g2_decap_8
XFILLER_10_206 VDD VSS sg13g2_fill_2
XFILLER_11_718 VDD VSS sg13g2_fill_2
X_3978_ _3977_/X _3978_/A1 _3985_/B _4831_/D VDD VSS sg13g2_mux2_1
XFILLER_109_606 VDD VSS sg13g2_decap_8
X_2929_ _2956_/B _4796_/Q _4795_/Q VDD VSS sg13g2_nand2b_1
XFILLER_108_127 VDD VSS sg13g2_decap_8
XFILLER_40_48 VDD VSS sg13g2_decap_8
XFILLER_104_322 VDD VSS sg13g2_decap_8
XFILLER_105_845 VDD VSS sg13g2_decap_8
XFILLER_116_193 VDD VSS sg13g2_decap_8
XFILLER_105_63 VDD VSS sg13g2_decap_8
XFILLER_19_818 VDD VSS sg13g2_decap_8
XFILLER_74_924 VDD VSS sg13g2_fill_2
XFILLER_18_339 VDD VSS sg13g2_fill_1
XFILLER_45_103 VDD VSS sg13g2_decap_4
XFILLER_65_56 VDD VSS sg13g2_decap_8
XFILLER_73_467 VDD VSS sg13g2_fill_2
XFILLER_14_523 VDD VSS sg13g2_decap_8
XFILLER_41_320 VDD VSS sg13g2_decap_8
XFILLER_42_843 VDD VSS sg13g2_decap_8
XFILLER_53_180 VDD VSS sg13g2_decap_8
XFILLER_42_898 VDD VSS sg13g2_decap_8
XFILLER_81_66 VDD VSS sg13g2_decap_8
XFILLER_10_751 VDD VSS sg13g2_decap_8
XFILLER_6_700 VDD VSS sg13g2_decap_8
XFILLER_6_777 VDD VSS sg13g2_decap_8
XFILLER_107_160 VDD VSS sg13g2_decap_8
XFILLER_108_694 VDD VSS sg13g2_decap_8
XFILLER_69_718 VDD VSS sg13g2_decap_8
XFILLER_39_7 VDD VSS sg13g2_decap_8
XFILLER_68_228 VDD VSS sg13g2_decap_8
XFILLER_96_537 VDD VSS sg13g2_decap_8
XFILLER_110_325 VDD VSS sg13g2_decap_8
XFILLER_49_431 VDD VSS sg13g2_decap_8
XFILLER_37_604 VDD VSS sg13g2_decap_8
XFILLER_77_762 VDD VSS sg13g2_decap_8
XFILLER_49_486 VDD VSS sg13g2_decap_8
XFILLER_18_862 VDD VSS sg13g2_decap_8
XFILLER_36_136 VDD VSS sg13g2_decap_8
XFILLER_64_445 VDD VSS sg13g2_fill_1
XFILLER_17_361 VDD VSS sg13g2_decap_8
XFILLER_18_873 VDD VSS sg13g2_fill_1
XFILLER_45_670 VDD VSS sg13g2_decap_8
XFILLER_51_106 VDD VSS sg13g2_decap_8
X_4950_ fanout276/X VSS VDD _4950_/D _4950_/Q _4950_/CLK sg13g2_dfrbpq_1
XFILLER_91_286 VDD VSS sg13g2_decap_8
X_4881_ fanout303/X VSS VDD _4881_/D _4881_/Q _4884_/CLK sg13g2_dfrbpq_1
X_4269__457 VDD VSS _4269_/RESET_B sg13g2_tiehi
X_3901_ _3901_/A _3901_/B _3901_/C _3901_/D _3918_/D VDD VSS sg13g2_nor4_1
X_3832_ _3832_/A _3832_/B _3832_/X VDD VSS sg13g2_and2_1
XFILLER_20_526 VDD VSS sg13g2_decap_8
XFILLER_32_397 VDD VSS sg13g2_decap_8
X_3763_ _3763_/Y _3800_/A _3788_/B VDD VSS sg13g2_nand2_1
XFILLER_65_0 VDD VSS sg13g2_decap_8
X_3694_ _4732_/Q _3694_/C _3694_/A _3694_/Y VDD VSS sg13g2_nand3_1
X_2714_ _2790_/A _2787_/A _2714_/B VDD VSS sg13g2_nand2_1
X_2645_ _2645_/A _4857_/Q _2645_/Y VDD VSS sg13g2_nor2_1
X_4315_ _4315_/RESET_B VSS VDD _4315_/D _4315_/Q _4964_/CLK sg13g2_dfrbpq_1
X_2576_ _2583_/D _2576_/A _2576_/B _2576_/C VDD VSS sg13g2_and3_1
XFILLER_99_331 VDD VSS sg13g2_decap_4
XFILLER_87_526 VDD VSS sg13g2_decap_8
XFILLER_68_751 VDD VSS sg13g2_decap_8
X_4246_ _4246_/Y _4246_/B _4147_/B1 VDD VSS sg13g2_nand2b_1
XFILLER_101_358 VDD VSS sg13g2_decap_8
XFILLER_110_870 VDD VSS sg13g2_fill_2
XFILLER_19_49 VDD VSS sg13g2_decap_8
XFILLER_68_762 VDD VSS sg13g2_fill_1
X_4177_ VSS VDD _4225_/A1 _4175_/X _4177_/Y _4176_/Y sg13g2_a21oi_1
XFILLER_28_648 VDD VSS sg13g2_decap_8
XFILLER_55_434 VDD VSS sg13g2_decap_8
XFILLER_67_272 VDD VSS sg13g2_decap_8
X_3128_ _3128_/Y _3128_/A _3128_/B VDD VSS sg13g2_nand2_1
XFILLER_95_592 VDD VSS sg13g2_fill_1
XFILLER_27_158 VDD VSS sg13g2_decap_8
XFILLER_35_15 VDD VSS sg13g2_fill_2
XFILLER_24_821 VDD VSS sg13g2_fill_2
X_3059_ _4017_/B _2466_/A _3085_/S _4485_/D VDD VSS sg13g2_mux2_1
XFILLER_24_854 VDD VSS sg13g2_decap_8
XFILLER_42_128 VDD VSS sg13g2_decap_8
XFILLER_51_640 VDD VSS sg13g2_decap_8
XFILLER_70_448 VDD VSS sg13g2_fill_1
XFILLER_82_297 VDD VSS sg13g2_decap_8
XFILLER_23_342 VDD VSS sg13g2_decap_8
XFILLER_11_537 VDD VSS sg13g2_decap_4
XFILLER_50_183 VDD VSS sg13g2_decap_8
XFILLER_51_14 VDD VSS sg13g2_fill_1
XFILLER_51_36 VDD VSS sg13g2_decap_8
XFILLER_109_447 VDD VSS sg13g2_decap_8
XFILLER_105_642 VDD VSS sg13g2_decap_8
XFILLER_3_758 VDD VSS sg13g2_decap_8
XFILLER_78_526 VDD VSS sg13g2_decap_8
XFILLER_116_84 VDD VSS sg13g2_decap_8
XFILLER_47_924 VDD VSS sg13g2_fill_2
XFILLER_101_892 VDD VSS sg13g2_decap_8
XFILLER_18_147 VDD VSS sg13g2_decap_8
XFILLER_19_659 VDD VSS sg13g2_fill_1
XFILLER_46_456 VDD VSS sg13g2_decap_8
XFILLER_46_467 VDD VSS sg13g2_decap_4
XFILLER_73_253 VDD VSS sg13g2_decap_8
XFILLER_15_810 VDD VSS sg13g2_decap_8
XFILLER_27_681 VDD VSS sg13g2_fill_1
XFILLER_33_117 VDD VSS sg13g2_decap_8
XFILLER_74_787 VDD VSS sg13g2_decap_8
XFILLER_61_448 VDD VSS sg13g2_decap_8
XFILLER_73_297 VDD VSS sg13g2_fill_1
XFILLER_15_887 VDD VSS sg13g2_decap_4
XFILLER_14_375 VDD VSS sg13g2_fill_2
XFILLER_30_857 VDD VSS sg13g2_decap_8
XFILLER_42_695 VDD VSS sg13g2_decap_8
XFILLER_10_592 VDD VSS sg13g2_decap_8
XFILLER_6_552 VDD VSS sg13g2_decap_8
X_2430_ _2800_/A _2800_/B _2801_/B VDD VSS sg13g2_and2_1
XFILLER_108_491 VDD VSS sg13g2_decap_8
X_2361_ _2361_/Y _4666_/Q _4658_/Q VDD VSS sg13g2_nand2_1
XFILLER_96_301 VDD VSS sg13g2_decap_8
X_4100_ _4100_/B _4100_/C _4121_/A _4100_/Y VDD VSS sg13g2_nand3_1
X_2292_ VDD _3786_/A _2292_/A VSS sg13g2_inv_1
XFILLER_97_857 VDD VSS sg13g2_decap_8
XFILLER_110_133 VDD VSS sg13g2_decap_8
XFILLER_110_144 VDD VSS sg13g2_fill_1
XFILLER_111_689 VDD VSS sg13g2_decap_8
X_4031_ hold834/X _4031_/A1 _4038_/A _4031_/X VDD VSS sg13g2_mux2_1
XFILLER_96_356 VDD VSS sg13g2_decap_8
XFILLER_110_199 VDD VSS sg13g2_decap_8
XFILLER_65_710 VDD VSS sg13g2_decap_8
XFILLER_77_570 VDD VSS sg13g2_decap_4
XFILLER_37_445 VDD VSS sg13g2_decap_8
XFILLER_64_242 VDD VSS sg13g2_fill_1
XFILLER_80_702 VDD VSS sg13g2_decap_8
XFILLER_92_540 VDD VSS sg13g2_fill_1
XFILLER_24_117 VDD VSS sg13g2_decap_8
XFILLER_37_478 VDD VSS sg13g2_decap_4
XFILLER_92_573 VDD VSS sg13g2_decap_8
X_4933_ fanout335/X VSS VDD _4933_/D _4933_/Q _4933_/CLK sg13g2_dfrbpq_1
XFILLER_80_779 VDD VSS sg13g2_decap_8
XFILLER_32_161 VDD VSS sg13g2_decap_8
XFILLER_60_481 VDD VSS sg13g2_decap_8
X_4864_ fanout326/X VSS VDD _4864_/D _4864_/Q _4870_/CLK sg13g2_dfrbpq_1
XFILLER_20_356 VDD VSS sg13g2_decap_8
XFILLER_21_857 VDD VSS sg13g2_decap_8
X_4795_ fanout315/X VSS VDD _4795_/D _4795_/Q _4931_/CLK sg13g2_dfrbpq_1
X_3815_ _3827_/A VDD _3815_/Y VSS _3793_/Y _3814_/Y sg13g2_o21ai_1
X_3746_ _3746_/A _3753_/A _3751_/C _3746_/X VDD VSS sg13g2_or3_1
X_3677_ _3677_/Y _3677_/A _3677_/B VDD VSS sg13g2_nand2_1
X_2628_ _4828_/Q _4829_/Q _2634_/A _2628_/Y VDD VSS sg13g2_nand3_1
XFILLER_102_601 VDD VSS sg13g2_fill_1
X_2559_ _2561_/C _2561_/A _2559_/X VDD VSS sg13g2_xor2_1
XFILLER_99_161 VDD VSS sg13g2_decap_8
XFILLER_0_739 VDD VSS sg13g2_decap_8
X_4229_ _4228_/Y VDD _4229_/Y VSS _4225_/Y _4227_/Y sg13g2_o21ai_1
XFILLER_28_412 VDD VSS sg13g2_fill_1
XFILLER_46_14 VDD VSS sg13g2_decap_8
XFILLER_44_916 VDD VSS sg13g2_decap_8
XFILLER_55_220 VDD VSS sg13g2_decap_8
XFILLER_56_754 VDD VSS sg13g2_decap_8
XFILLER_55_253 VDD VSS sg13g2_decap_8
XFILLER_56_798 VDD VSS sg13g2_decap_8
XFILLER_71_724 VDD VSS sg13g2_fill_2
XFILLER_102_42 VDD VSS sg13g2_decap_8
XFILLER_70_245 VDD VSS sg13g2_decap_8
XFILLER_62_35 VDD VSS sg13g2_decap_8
XFILLER_62_46 VDD VSS sg13g2_fill_1
XFILLER_70_256 VDD VSS sg13g2_decap_8
XFILLER_23_150 VDD VSS sg13g2_decap_8
XFILLER_7_305 VDD VSS sg13g2_fill_1
XFILLER_109_244 VDD VSS sg13g2_fill_2
XFILLER_109_266 VDD VSS sg13g2_decap_8
XFILLER_7_349 VDD VSS sg13g2_decap_8
XFILLER_11_83 VDD VSS sg13g2_decap_8
XFILLER_79_802 VDD VSS sg13g2_decap_4
XFILLER_87_21 VDD VSS sg13g2_decap_8
XFILLER_105_483 VDD VSS sg13g2_decap_8
XFILLER_79_868 VDD VSS sg13g2_decap_8
XFILLER_38_209 VDD VSS sg13g2_decap_8
XFILLER_19_412 VDD VSS sg13g2_decap_8
XFILLER_59_570 VDD VSS sg13g2_fill_1
XFILLER_78_389 VDD VSS sg13g2_decap_8
XFILLER_94_849 VDD VSS sg13g2_decap_8
XFILLER_87_890 VDD VSS sg13g2_fill_1
XFILLER_47_754 VDD VSS sg13g2_decap_8
XFILLER_74_551 VDD VSS sg13g2_decap_4
XFILLER_19_467 VDD VSS sg13g2_decap_8
XFILLER_74_562 VDD VSS sg13g2_fill_1
XFILLER_61_234 VDD VSS sg13g2_decap_8
XFILLER_15_640 VDD VSS sg13g2_decap_8
XFILLER_62_779 VDD VSS sg13g2_decap_8
XFILLER_14_161 VDD VSS sg13g2_decap_8
X_4580_ fanout329/X VSS VDD _4580_/D _4580_/Q _4580_/CLK sg13g2_dfrbpq_1
X_3600_ _3600_/A _3600_/B _4725_/D VDD VSS sg13g2_and2_1
X_3531_ _4693_/Q _3531_/A1 _3551_/S _3531_/X VDD VSS sg13g2_mux2_1
XFILLER_7_872 VDD VSS sg13g2_decap_8
Xhold828 _4664_/Q VDD VSS _3451_/A sg13g2_dlygate4sd3_1
Xhold817 _4427_/Q VDD VSS _4173_/B sg13g2_dlygate4sd3_1
Xhold806 _4829_/Q VDD VSS _3972_/C sg13g2_dlygate4sd3_1
XFILLER_115_225 VDD VSS sg13g2_decap_8
XFILLER_6_382 VDD VSS sg13g2_decap_4
Xhold839 _4414_/Q VDD VSS hold839/X sg13g2_dlygate4sd3_1
X_3462_ _3461_/Y VDD _3462_/Y VSS _2280_/Y _3477_/C sg13g2_o21ai_1
X_3393_ _4775_/Q _4903_/Q _3393_/C _3410_/C VDD VSS sg13g2_nor3_1
X_2413_ _2814_/A _2814_/B _2413_/A _2818_/B VDD VSS sg13g2_nand3_1
XFILLER_69_334 VDD VSS sg13g2_decap_8
X_2344_ VDD _3991_/B _2344_/A VSS sg13g2_inv_1
XFILLER_28_0 VDD VSS sg13g2_decap_8
Xhold1506 _4858_/Q VDD VSS _2646_/A1 sg13g2_dlygate4sd3_1
Xhold1517 _4939_/Q VDD VSS _2777_/A sg13g2_dlygate4sd3_1
XFILLER_96_142 VDD VSS sg13g2_fill_2
XFILLER_96_131 VDD VSS sg13g2_decap_8
XFILLER_85_827 VDD VSS sg13g2_decap_8
XFILLER_111_497 VDD VSS sg13g2_decap_8
Xhold1528 _4566_/Q VDD VSS _3158_/A sg13g2_dlygate4sd3_1
Xhold1539 _4620_/Q VDD VSS _3286_/A sg13g2_dlygate4sd3_1
X_2275_ VDD _2275_/Y _3455_/A VSS sg13g2_inv_1
XFILLER_38_765 VDD VSS sg13g2_decap_8
X_4014_ _4189_/B1 VDD _4014_/Y VSS _4011_/Y _4012_/Y sg13g2_o21ai_1
XFILLER_53_713 VDD VSS sg13g2_decap_4
XFILLER_53_779 VDD VSS sg13g2_fill_2
XFILLER_21_621 VDD VSS sg13g2_decap_8
XFILLER_33_481 VDD VSS sg13g2_decap_8
X_4916_ fanout261/X VSS VDD _4916_/D _4916_/Q clkload7/A sg13g2_dfrbpq_1
XFILLER_20_120 VDD VSS sg13g2_fill_2
XFILLER_20_131 VDD VSS sg13g2_fill_2
X_4847_ fanout331/X VSS VDD _4847_/D _4847_/Q _4955_/CLK sg13g2_dfrbpq_1
XFILLER_20_164 VDD VSS sg13g2_decap_8
XFILLER_20_175 VDD VSS sg13g2_fill_2
XFILLER_21_698 VDD VSS sg13g2_decap_8
XFILLER_5_809 VDD VSS sg13g2_decap_8
X_4778_ fanout259/X VSS VDD _4778_/D _4778_/Q _4907_/CLK sg13g2_dfrbpq_1
XFILLER_106_203 VDD VSS sg13g2_decap_8
X_3729_ _3729_/Y _3792_/B _3788_/B VDD VSS sg13g2_nand2_1
XFILLER_106_269 VDD VSS sg13g2_decap_4
XFILLER_0_536 VDD VSS sg13g2_decap_8
XFILLER_102_486 VDD VSS sg13g2_decap_8
XFILLER_57_68 VDD VSS sg13g2_decap_8
XFILLER_76_838 VDD VSS sg13g2_decap_8
XFILLER_28_220 VDD VSS sg13g2_decap_8
XFILLER_29_743 VDD VSS sg13g2_decap_8
XFILLER_29_798 VDD VSS sg13g2_decap_8
XFILLER_84_893 VDD VSS sg13g2_decap_8
XFILLER_90_307 VDD VSS sg13g2_decap_8
XFILLER_28_286 VDD VSS sg13g2_decap_8
XFILLER_56_595 VDD VSS sg13g2_decap_8
XFILLER_71_543 VDD VSS sg13g2_fill_2
XFILLER_73_56 VDD VSS sg13g2_decap_8
XFILLER_83_392 VDD VSS sg13g2_decap_4
XFILLER_43_256 VDD VSS sg13g2_fill_2
XFILLER_12_654 VDD VSS sg13g2_decap_8
XFILLER_11_186 VDD VSS sg13g2_decap_8
XFILLER_8_669 VDD VSS sg13g2_fill_2
XFILLER_8_658 VDD VSS sg13g2_fill_2
XFILLER_4_886 VDD VSS sg13g2_decap_8
XFILLER_105_291 VDD VSS sg13g2_decap_8
XFILLER_21_7 VDD VSS sg13g2_decap_4
XFILLER_35_713 VDD VSS sg13g2_decap_8
XFILLER_81_329 VDD VSS sg13g2_decap_8
XFILLER_93_178 VDD VSS sg13g2_decap_8
XFILLER_19_275 VDD VSS sg13g2_fill_1
XFILLER_90_852 VDD VSS sg13g2_decap_8
XFILLER_22_407 VDD VSS sg13g2_decap_8
XFILLER_34_278 VDD VSS sg13g2_decap_8
X_2962_ _2962_/A0 _3091_/A0 _2980_/S _2962_/X VDD VSS sg13g2_mux2_1
XFILLER_30_440 VDD VSS sg13g2_decap_8
X_4701_ fanout323/X VSS VDD _4701_/D _4701_/Q _4729_/CLK sg13g2_dfrbpq_1
X_4632_ fanout265/X VSS VDD _4632_/D _4632_/Q _4658_/CLK sg13g2_dfrbpq_1
X_2893_ hold836/X _3101_/A0 _2902_/S _2893_/X VDD VSS sg13g2_mux2_1
XFILLER_30_495 VDD VSS sg13g2_decap_8
XFILLER_116_512 VDD VSS sg13g2_decap_8
Xhold603 _3727_/Y VDD VSS _4756_/D sg13g2_dlygate4sd3_1
X_4563_ fanout317/X VSS VDD _4563_/D _4563_/Q _4929_/CLK sg13g2_dfrbpq_1
Xhold614 _3677_/Y VDD VSS hold614/X sg13g2_dlygate4sd3_1
Xhold625 _2555_/X VDD VSS _4881_/D sg13g2_dlygate4sd3_1
Xhold636 _4887_/Q VDD VSS _2571_/A sg13g2_dlygate4sd3_1
X_4494_ fanout312/X VSS VDD _4494_/D _4494_/Q _4961_/CLK sg13g2_dfrbpq_1
X_3514_ _3514_/Y _3514_/A _3514_/B VDD VSS sg13g2_xnor2_1
Xhold669 _3355_/Y VDD VSS _4636_/D sg13g2_dlygate4sd3_1
Xhold658 _2575_/Y VDD VSS _2577_/A sg13g2_dlygate4sd3_1
Xhold647 _4211_/Y VDD VSS _4974_/D sg13g2_dlygate4sd3_1
X_3445_ _3471_/B _3447_/C _3445_/A _3445_/Y VDD VSS sg13g2_nand3_1
XFILLER_103_217 VDD VSS sg13g2_decap_8
XFILLER_103_239 VDD VSS sg13g2_decap_8
X_3376_ _3424_/A _3424_/B _3376_/Y VDD VSS sg13g2_nor2_1
XFILLER_97_462 VDD VSS sg13g2_decap_8
XFILLER_69_186 VDD VSS sg13g2_decap_8
Xhold1303 _4524_/Q VDD VSS hold1303/X sg13g2_dlygate4sd3_1
Xhold1314 _3442_/Y VDD VSS _4658_/D sg13g2_dlygate4sd3_1
Xhold1325 _4675_/Q VDD VSS _3473_/A sg13g2_dlygate4sd3_1
X_2327_ VDD _2327_/Y _2327_/A VSS sg13g2_inv_1
XFILLER_85_635 VDD VSS sg13g2_decap_8
XFILLER_57_348 VDD VSS sg13g2_decap_8
Xhold1336 _3116_/X VDD VSS _4540_/D sg13g2_dlygate4sd3_1
Xhold1347 _3866_/B VDD VSS _4853_/D sg13g2_dlygate4sd3_1
Xhold1358 _2729_/Y VDD VSS _2731_/B sg13g2_dlygate4sd3_1
X_2258_ VDD _3162_/A _2258_/A VSS sg13g2_inv_1
XFILLER_26_702 VDD VSS sg13g2_decap_4
XFILLER_27_49 VDD VSS sg13g2_decap_8
XFILLER_38_573 VDD VSS sg13g2_fill_2
Xhold1369 _3263_/Y VDD VSS _3264_/B sg13g2_dlygate4sd3_1
XFILLER_26_724 VDD VSS sg13g2_decap_4
XFILLER_26_735 VDD VSS sg13g2_fill_1
XFILLER_38_595 VDD VSS sg13g2_fill_2
XFILLER_84_189 VDD VSS sg13g2_fill_1
XFILLER_13_407 VDD VSS sg13g2_decap_8
XFILLER_25_234 VDD VSS sg13g2_decap_4
XFILLER_81_863 VDD VSS sg13g2_decap_8
XFILLER_40_215 VDD VSS sg13g2_decap_8
XFILLER_41_738 VDD VSS sg13g2_decap_4
XFILLER_80_384 VDD VSS sg13g2_decap_8
XFILLER_34_790 VDD VSS sg13g2_decap_8
XFILLER_21_462 VDD VSS sg13g2_decap_8
XFILLER_107_578 VDD VSS sg13g2_decap_8
XFILLER_108_30 VDD VSS sg13g2_fill_1
XFILLER_1_845 VDD VSS sg13g2_decap_8
X_4295__431 VDD VSS _4295_/RESET_B sg13g2_tiehi
XFILLER_0_333 VDD VSS sg13g2_decap_8
XFILLER_68_67 VDD VSS sg13g2_decap_8
XFILLER_88_440 VDD VSS sg13g2_decap_4
XFILLER_102_250 VDD VSS sg13g2_decap_8
XFILLER_102_261 VDD VSS sg13g2_fill_1
XFILLER_84_22 VDD VSS sg13g2_fill_1
XFILLER_29_551 VDD VSS sg13g2_decap_8
XFILLER_75_156 VDD VSS sg13g2_decap_8
XFILLER_76_679 VDD VSS sg13g2_decap_8
XFILLER_17_746 VDD VSS sg13g2_decap_8
XFILLER_63_329 VDD VSS sg13g2_decap_8
XFILLER_91_638 VDD VSS sg13g2_decap_8
XFILLER_17_82 VDD VSS sg13g2_decap_4
XFILLER_44_565 VDD VSS sg13g2_fill_1
XFILLER_16_278 VDD VSS sg13g2_decap_8
XFILLER_31_226 VDD VSS sg13g2_decap_8
XFILLER_9_912 VDD VSS sg13g2_decap_8
XFILLER_12_484 VDD VSS sg13g2_decap_8
XFILLER_12_495 VDD VSS sg13g2_fill_2
XFILLER_8_433 VDD VSS sg13g2_decap_8
XFILLER_8_477 VDD VSS sg13g2_decap_8
XFILLER_99_716 VDD VSS sg13g2_fill_1
XFILLER_113_526 VDD VSS sg13g2_decap_8
XFILLER_4_683 VDD VSS sg13g2_decap_8
X_3230_ _3230_/A _3230_/B _4597_/D VDD VSS sg13g2_nor2_1
XFILLER_98_259 VDD VSS sg13g2_decap_8
XFILLER_79_484 VDD VSS sg13g2_fill_2
X_3161_ VSS VDD _3162_/B hold761/X _3161_/Y _3182_/A sg13g2_a21oi_1
XFILLER_39_348 VDD VSS sg13g2_decap_8
XFILLER_94_421 VDD VSS sg13g2_decap_8
XFILLER_48_871 VDD VSS sg13g2_decap_8
XFILLER_66_156 VDD VSS sg13g2_decap_8
XFILLER_81_104 VDD VSS sg13g2_decap_8
X_3092_ _3092_/A0 _3117_/A1 _3104_/S _4516_/D VDD VSS sg13g2_mux2_1
XFILLER_94_498 VDD VSS sg13g2_decap_4
XFILLER_63_863 VDD VSS sg13g2_decap_8
XFILLER_90_682 VDD VSS sg13g2_decap_8
XFILLER_22_248 VDD VSS sg13g2_decap_8
XFILLER_50_546 VDD VSS sg13g2_decap_8
XFILLER_62_395 VDD VSS sg13g2_decap_8
X_3994_ _3993_/Y VDD _3994_/Y VSS _3985_/B _3992_/Y sg13g2_o21ai_1
XFILLER_95_0 VDD VSS sg13g2_decap_8
XFILLER_13_29 VDD VSS sg13g2_decap_8
X_2945_ hold994/X _3100_/A0 _2953_/S _2945_/X VDD VSS sg13g2_mux2_1
XFILLER_30_281 VDD VSS sg13g2_decap_8
X_2876_ _2903_/B _4795_/Q _4796_/Q VDD VSS sg13g2_nand2b_1
X_4615_ fanout282/X VSS VDD _4615_/D _4615_/Q _4619_/CLK sg13g2_dfrbpq_1
XFILLER_116_331 VDD VSS sg13g2_decap_8
X_4546_ fanout296/X VSS VDD _4546_/D _4546_/Q _4960_/CLK sg13g2_dfrbpq_1
XFILLER_116_342 VDD VSS sg13g2_fill_1
XFILLER_89_204 VDD VSS sg13g2_decap_8
X_4477_ fanout323/X VSS VDD _4477_/D _4477_/Q _4972_/CLK sg13g2_dfrbpq_1
XFILLER_89_237 VDD VSS sg13g2_decap_8
X_3428_ _3427_/Y VDD _3428_/Y VSS _2262_/Y _3443_/C sg13g2_o21ai_1
Xhold1100 _4345_/Q VDD VSS _2913_/A0 sg13g2_dlygate4sd3_1
X_3359_ _4637_/D _3408_/A _3359_/B _3361_/B VDD VSS sg13g2_and3_1
XFILLER_46_808 VDD VSS sg13g2_fill_1
XFILLER_58_657 VDD VSS sg13g2_decap_4
Xhold1111 _4270_/Q VDD VSS _2833_/A0 sg13g2_dlygate4sd3_1
Xhold1122 _3020_/X VDD VSS _4446_/D sg13g2_dlygate4sd3_1
Xhold1133 _4541_/Q VDD VSS _3117_/A1 sg13g2_dlygate4sd3_1
XFILLER_85_443 VDD VSS sg13g2_decap_8
XFILLER_39_871 VDD VSS sg13g2_fill_1
XFILLER_45_318 VDD VSS sg13g2_decap_8
XFILLER_57_178 VDD VSS sg13g2_fill_2
XFILLER_73_605 VDD VSS sg13g2_decap_8
Xhold1144 _4311_/Q VDD VSS _2878_/A0 sg13g2_dlygate4sd3_1
Xhold1155 _4381_/Q VDD VSS _2951_/A0 sg13g2_dlygate4sd3_1
Xhold1166 _2967_/X VDD VSS _4396_/D sg13g2_dlygate4sd3_1
XFILLER_100_798 VDD VSS sg13g2_decap_8
XFILLER_45_329 VDD VSS sg13g2_fill_2
XFILLER_54_14 VDD VSS sg13g2_decap_8
XFILLER_72_137 VDD VSS sg13g2_decap_8
Xhold1177 _4443_/Q VDD VSS _3017_/A0 sg13g2_dlygate4sd3_1
Xhold1188 _4373_/Q VDD VSS _2943_/A0 sg13g2_dlygate4sd3_1
Xhold1199 _4281_/Q VDD VSS _2844_/A0 sg13g2_dlygate4sd3_1
XFILLER_54_874 VDD VSS sg13g2_fill_2
XFILLER_81_660 VDD VSS sg13g2_fill_2
XFILLER_41_502 VDD VSS sg13g2_fill_1
XFILLER_54_896 VDD VSS sg13g2_decap_8
XFILLER_110_42 VDD VSS sg13g2_decap_8
XFILLER_13_226 VDD VSS sg13g2_decap_8
XFILLER_14_749 VDD VSS sg13g2_decap_8
XFILLER_53_395 VDD VSS sg13g2_decap_8
XFILLER_80_192 VDD VSS sg13g2_decap_8
XFILLER_41_568 VDD VSS sg13g2_decap_8
XFILLER_70_68 VDD VSS sg13g2_fill_1
XFILLER_108_843 VDD VSS sg13g2_decap_8
XFILLER_107_386 VDD VSS sg13g2_fill_1
XFILLER_79_55 VDD VSS sg13g2_decap_8
XFILLER_77_900 VDD VSS sg13g2_decap_8
XFILLER_95_21 VDD VSS sg13g2_decap_8
XFILLER_89_782 VDD VSS sg13g2_fill_2
XFILLER_88_270 VDD VSS sg13g2_decap_8
XFILLER_0_196 VDD VSS sg13g2_decap_8
XFILLER_37_808 VDD VSS sg13g2_decap_8
XFILLER_49_657 VDD VSS sg13g2_fill_1
XFILLER_76_454 VDD VSS sg13g2_decap_8
XFILLER_45_830 VDD VSS sg13g2_fill_1
XFILLER_48_178 VDD VSS sg13g2_decap_8
XFILLER_57_690 VDD VSS sg13g2_decap_8
XFILLER_63_115 VDD VSS sg13g2_decap_4
XFILLER_17_543 VDD VSS sg13g2_fill_2
XFILLER_29_392 VDD VSS sg13g2_decap_8
XFILLER_45_852 VDD VSS sg13g2_decap_8
XFILLER_91_457 VDD VSS sg13g2_decap_8
XFILLER_44_362 VDD VSS sg13g2_fill_2
XFILLER_60_822 VDD VSS sg13g2_fill_2
XFILLER_72_671 VDD VSS sg13g2_decap_8
XFILLER_44_91 VDD VSS sg13g2_fill_1
XFILLER_13_782 VDD VSS sg13g2_decap_8
X_2730_ _2730_/A _4944_/Q _4945_/Q _2730_/D _2733_/B VDD VSS sg13g2_and4_1
XFILLER_8_230 VDD VSS sg13g2_decap_8
X_2661_ _2661_/Y _4704_/Q _2677_/A VDD VSS sg13g2_nand2b_1
XFILLER_9_786 VDD VSS sg13g2_fill_2
X_4400_ _4400_/RESET_B VSS VDD _4400_/D _4400_/Q _4977_/CLK sg13g2_dfrbpq_1
X_2592_ _2592_/B _3206_/A _2592_/A _3208_/B VDD VSS _3202_/B sg13g2_nand4_1
XFILLER_99_502 VDD VSS sg13g2_decap_8
X_4331_ _4331_/RESET_B VSS VDD _4331_/D _4331_/Q _4976_/CLK sg13g2_dfrbpq_1
XFILLER_4_480 VDD VSS sg13g2_fill_1
XFILLER_5_85 VDD VSS sg13g2_decap_4
Xfanout209 _4739_/Q _3717_/A VDD VSS sg13g2_buf_1
X_4262_ _4262_/RESET_B VSS VDD _4262_/D _4262_/Q clkload8/A sg13g2_dfrbpq_1
XFILLER_99_579 VDD VSS sg13g2_decap_8
XFILLER_87_719 VDD VSS sg13g2_decap_8
XFILLER_101_507 VDD VSS sg13g2_decap_8
X_3213_ _3213_/Y _3213_/A _3213_/B VDD VSS sg13g2_xnor2_1
XFILLER_86_218 VDD VSS sg13g2_decap_8
XFILLER_79_281 VDD VSS sg13g2_fill_2
XFILLER_79_292 VDD VSS sg13g2_decap_8
X_4193_ _4192_/Y VDD _4193_/Y VSS _4190_/Y _4191_/Y sg13g2_o21ai_1
XFILLER_10_0 VDD VSS sg13g2_decap_8
XFILLER_67_476 VDD VSS sg13g2_decap_8
X_3144_ _3144_/A _3145_/B _3185_/A VDD VSS sg13g2_and2_1
XFILLER_95_763 VDD VSS sg13g2_decap_8
XFILLER_36_830 VDD VSS sg13g2_decap_8
XFILLER_82_424 VDD VSS sg13g2_decap_8
X_3075_ _4157_/B _3075_/A1 _3083_/S _4499_/D VDD VSS sg13g2_mux2_1
XFILLER_51_833 VDD VSS sg13g2_fill_1
XFILLER_50_321 VDD VSS sg13g2_decap_8
XFILLER_51_844 VDD VSS sg13g2_decap_8
X_4285__441 VDD VSS _4285_/RESET_B sg13g2_tiehi
X_3977_ _3677_/A _3981_/A _3977_/S _3977_/X VDD VSS sg13g2_mux2_1
X_2928_ _2928_/A0 _3110_/A0 _2928_/S _2928_/X VDD VSS sg13g2_mux2_1
X_2859_ _2859_/A0 _3094_/A0 _2875_/S _2859_/X VDD VSS sg13g2_mux2_1
XFILLER_104_301 VDD VSS sg13g2_decap_8
XFILLER_116_172 VDD VSS sg13g2_decap_8
X_4529_ fanout297/X VSS VDD _4529_/D _4529_/Q _4960_/CLK sg13g2_dfrbpq_1
XFILLER_77_229 VDD VSS sg13g2_decap_8
X_4292__434 VDD VSS _4292_/RESET_B sg13g2_tiehi
XFILLER_100_573 VDD VSS sg13g2_decap_8
XFILLER_65_35 VDD VSS sg13g2_decap_8
XFILLER_73_413 VDD VSS sg13g2_fill_2
XFILLER_27_863 VDD VSS sg13g2_decap_8
XFILLER_45_137 VDD VSS sg13g2_decap_8
XFILLER_27_874 VDD VSS sg13g2_fill_1
XFILLER_42_811 VDD VSS sg13g2_decap_4
XFILLER_61_619 VDD VSS sg13g2_fill_1
XFILLER_26_395 VDD VSS sg13g2_decap_8
XFILLER_81_45 VDD VSS sg13g2_decap_8
XFILLER_14_579 VDD VSS sg13g2_decap_4
XFILLER_41_398 VDD VSS sg13g2_decap_8
XFILLER_5_200 VDD VSS sg13g2_decap_8
XFILLER_6_756 VDD VSS sg13g2_decap_8
XFILLER_5_288 VDD VSS sg13g2_decap_8
XFILLER_110_304 VDD VSS sg13g2_decap_8
XFILLER_1_472 VDD VSS sg13g2_decap_8
XFILLER_49_410 VDD VSS sg13g2_decap_8
XFILLER_49_465 VDD VSS sg13g2_decap_8
XFILLER_49_476 VDD VSS sg13g2_fill_1
XFILLER_65_925 VDD VSS sg13g2_fill_1
XFILLER_76_284 VDD VSS sg13g2_decap_8
XFILLER_18_841 VDD VSS sg13g2_decap_8
XFILLER_92_777 VDD VSS sg13g2_decap_4
XFILLER_91_254 VDD VSS sg13g2_decap_4
X_4880_ fanout303/X VSS VDD _4880_/D _4880_/Q _4884_/CLK sg13g2_dfrbpq_1
X_3900_ VSS VDD _4809_/D _3900_/B _3900_/A sg13g2_or2_1
XFILLER_32_343 VDD VSS sg13g2_decap_8
XFILLER_32_354 VDD VSS sg13g2_fill_1
XFILLER_32_365 VDD VSS sg13g2_fill_2
X_3831_ _4784_/D _3837_/B1 _3830_/Y _3837_/A2 _3337_/A VDD VSS sg13g2_a22oi_1
XFILLER_32_376 VDD VSS sg13g2_decap_8
X_3762_ _3758_/Y VDD _3762_/Y VSS _3766_/A1 _3761_/Y sg13g2_o21ai_1
X_3693_ _3693_/Y _3689_/X _3692_/Y _3677_/B _3979_/B VDD VSS sg13g2_a22oi_1
X_2713_ _2499_/B _3522_/C _2712_/Y _4860_/D VDD VSS sg13g2_a21o_1
X_2644_ VDD _4942_/D _3726_/B VSS sg13g2_inv_1
XFILLER_58_0 VDD VSS sg13g2_decap_8
X_2575_ VSS VDD _2576_/A _2576_/C _2575_/Y _2576_/B sg13g2_a21oi_1
XFILLER_99_310 VDD VSS sg13g2_decap_8
X_4314_ _4314_/RESET_B VSS VDD _4314_/D _4314_/Q clkload9/A sg13g2_dfrbpq_1
XFILLER_114_687 VDD VSS sg13g2_fill_1
XFILLER_101_337 VDD VSS sg13g2_decap_8
XFILLER_102_849 VDD VSS sg13g2_decap_8
XFILLER_113_175 VDD VSS sg13g2_fill_1
XFILLER_19_28 VDD VSS sg13g2_decap_8
X_4245_ _4245_/B1 VDD _4245_/Y VSS _4245_/A1 _4239_/X sg13g2_o21ai_1
XFILLER_56_914 VDD VSS sg13g2_decap_8
XFILLER_56_925 VDD VSS sg13g2_fill_1
X_4176_ _4227_/A1 VDD _4176_/Y VSS _4173_/Y _4174_/Y sg13g2_o21ai_1
XFILLER_28_627 VDD VSS sg13g2_decap_8
XFILLER_82_210 VDD VSS sg13g2_fill_1
X_3127_ _3625_/A1 _3127_/A1 _3138_/B _4551_/D VDD VSS sg13g2_mux2_1
XFILLER_71_917 VDD VSS sg13g2_decap_8
XFILLER_24_800 VDD VSS sg13g2_decap_8
XFILLER_42_107 VDD VSS sg13g2_decap_8
XFILLER_82_276 VDD VSS sg13g2_decap_8
XFILLER_83_799 VDD VSS sg13g2_decap_8
X_3058_ hold894/X hold794/X _3058_/S _4484_/D VDD VSS sg13g2_mux2_1
XFILLER_35_170 VDD VSS sg13g2_decap_8
Xclkbuf_leaf_62_clk clkbuf_4_0_0_clk/X clkload0/A VDD VSS sg13g2_buf_8
XFILLER_23_387 VDD VSS sg13g2_decap_8
XFILLER_50_162 VDD VSS sg13g2_decap_8
XFILLER_51_26 VDD VSS sg13g2_fill_1
XFILLER_51_696 VDD VSS sg13g2_decap_8
XFILLER_109_415 VDD VSS sg13g2_decap_8
XFILLER_7_509 VDD VSS sg13g2_decap_8
XFILLER_105_621 VDD VSS sg13g2_decap_8
XFILLER_3_737 VDD VSS sg13g2_decap_8
XFILLER_78_505 VDD VSS sg13g2_decap_8
XFILLER_116_63 VDD VSS sg13g2_decap_8
XFILLER_46_402 VDD VSS sg13g2_decap_8
XFILLER_46_413 VDD VSS sg13g2_fill_2
XFILLER_61_427 VDD VSS sg13g2_decap_8
XFILLER_73_276 VDD VSS sg13g2_decap_8
XFILLER_27_693 VDD VSS sg13g2_fill_1
Xclkbuf_leaf_53_clk clkbuf_4_8_0_clk/X _4960_/CLK VDD VSS sg13g2_buf_8
XFILLER_92_77 VDD VSS sg13g2_decap_8
XFILLER_14_354 VDD VSS sg13g2_decap_8
XFILLER_15_866 VDD VSS sg13g2_decap_8
XFILLER_42_674 VDD VSS sg13g2_decap_8
XFILLER_30_836 VDD VSS sg13g2_decap_8
Xclkbuf_4_6_0_clk clkbuf_0_clk/X clkbuf_4_6_0_clk/X VDD VSS sg13g2_buf_8
XFILLER_116_908 VDD VSS sg13g2_decap_8
XFILLER_51_7 VDD VSS sg13g2_decap_8
X_2360_ _2360_/Y _4664_/Q _4656_/Q VDD VSS sg13g2_nand2_1
XFILLER_110_112 VDD VSS sg13g2_decap_8
XFILLER_2_792 VDD VSS sg13g2_decap_8
XFILLER_69_549 VDD VSS sg13g2_decap_8
X_2291_ VDD _2291_/Y _4674_/Q VSS sg13g2_inv_1
XFILLER_2_42 VDD VSS sg13g2_decap_8
X_4275__451 VDD VSS _4275_/RESET_B sg13g2_tiehi
X_4030_ _4172_/S1 VDD _4030_/Y VSS _4205_/A1 _4030_/A2 sg13g2_o21ai_1
XFILLER_38_925 VDD VSS sg13g2_fill_1
XFILLER_2_97 VDD VSS sg13g2_decap_4
XFILLER_37_457 VDD VSS sg13g2_decap_8
XFILLER_92_552 VDD VSS sg13g2_decap_8
XFILLER_52_427 VDD VSS sg13g2_decap_8
XFILLER_80_758 VDD VSS sg13g2_decap_8
Xclkbuf_leaf_44_clk clkbuf_4_11_0_clk/X _4894_/CLK VDD VSS sg13g2_buf_8
X_4932_ fanout335/X VSS VDD _4932_/D _4932_/Q _4933_/CLK sg13g2_dfrbpq_1
XFILLER_32_140 VDD VSS sg13g2_decap_8
XFILLER_21_836 VDD VSS sg13g2_decap_8
XFILLER_60_460 VDD VSS sg13g2_fill_1
X_4863_ fanout336/X VSS VDD _4863_/D _4863_/Q _4870_/CLK sg13g2_dfrbpq_1
XFILLER_20_335 VDD VSS sg13g2_decap_8
X_4794_ fanout315/X VSS VDD _4794_/D _4794_/Q _4931_/CLK sg13g2_dfrbpq_1
X_4282__444 VDD VSS _4282_/RESET_B sg13g2_tiehi
X_3814_ _3814_/A _4760_/Q _3814_/Y VDD VSS sg13g2_nor2b_1
X_3745_ _3751_/C _3796_/B _4761_/Q _3745_/C VDD VSS sg13g2_and3_1
X_3676_ _3675_/Y VDD _3676_/Y VSS _3659_/Y _3671_/Y sg13g2_o21ai_1
X_2627_ _2627_/Y _2721_/C _3972_/D VDD VSS sg13g2_nand2b_1
XFILLER_0_718 VDD VSS sg13g2_decap_8
X_2558_ _2561_/C _2558_/B _2558_/Y VDD VSS sg13g2_nor2_1
XFILLER_99_140 VDD VSS sg13g2_decap_8
XFILLER_102_646 VDD VSS sg13g2_decap_8
X_2489_ _3568_/A _4717_/Q _3563_/B _4718_/Q VDD VSS sg13g2_and3_1
XFILLER_101_145 VDD VSS sg13g2_decap_8
X_4228_ _4228_/Y _4228_/B _4227_/B1 VDD VSS sg13g2_nand2b_1
XFILLER_29_925 VDD VSS sg13g2_fill_1
XFILLER_56_733 VDD VSS sg13g2_decap_8
XFILLER_68_582 VDD VSS sg13g2_decap_4
XFILLER_96_891 VDD VSS sg13g2_decap_8
XFILLER_110_690 VDD VSS sg13g2_decap_8
XFILLER_83_552 VDD VSS sg13g2_decap_8
X_4159_ _4251_/S _4326_/Q _4159_/Y VDD VSS sg13g2_nor2_1
XFILLER_102_21 VDD VSS sg13g2_decap_8
XFILLER_71_703 VDD VSS sg13g2_decap_8
XFILLER_43_438 VDD VSS sg13g2_decap_8
XFILLER_70_224 VDD VSS sg13g2_decap_8
XFILLER_12_803 VDD VSS sg13g2_fill_1
XFILLER_62_14 VDD VSS sg13g2_decap_8
Xclkbuf_leaf_35_clk clkbuf_4_14_0_clk/X _4868_/CLK VDD VSS sg13g2_buf_8
XFILLER_102_98 VDD VSS sg13g2_decap_8
XFILLER_12_836 VDD VSS sg13g2_decap_4
XFILLER_24_685 VDD VSS sg13g2_fill_1
XFILLER_51_482 VDD VSS sg13g2_fill_2
XFILLER_11_357 VDD VSS sg13g2_decap_8
XFILLER_51_493 VDD VSS sg13g2_decap_8
XFILLER_109_223 VDD VSS sg13g2_decap_8
XFILLER_20_891 VDD VSS sg13g2_decap_8
XFILLER_105_462 VDD VSS sg13g2_fill_2
XFILLER_87_33 VDD VSS sg13g2_decap_8
XFILLER_79_847 VDD VSS sg13g2_decap_8
XFILLER_66_508 VDD VSS sg13g2_decap_8
XFILLER_78_368 VDD VSS sg13g2_decap_8
XFILLER_94_828 VDD VSS sg13g2_decap_8
XFILLER_47_700 VDD VSS sg13g2_fill_1
XFILLER_35_917 VDD VSS sg13g2_decap_8
XFILLER_46_243 VDD VSS sg13g2_fill_2
XFILLER_47_799 VDD VSS sg13g2_decap_8
XFILLER_34_449 VDD VSS sg13g2_decap_4
XFILLER_62_758 VDD VSS sg13g2_decap_8
XFILLER_74_596 VDD VSS sg13g2_decap_8
XFILLER_14_140 VDD VSS sg13g2_decap_8
XFILLER_36_92 VDD VSS sg13g2_decap_8
Xclkbuf_leaf_26_clk clkbuf_4_13_0_clk/X _4824_/CLK VDD VSS sg13g2_buf_8
XFILLER_99_7 VDD VSS sg13g2_decap_4
XFILLER_30_633 VDD VSS sg13g2_decap_8
XFILLER_30_688 VDD VSS sg13g2_decap_8
XFILLER_11_880 VDD VSS sg13g2_decap_8
XFILLER_7_851 VDD VSS sg13g2_decap_8
X_3530_ _4692_/Q hold906/X _3551_/S _3530_/X VDD VSS sg13g2_mux2_1
XFILLER_115_204 VDD VSS sg13g2_decap_8
XFILLER_6_361 VDD VSS sg13g2_decap_8
Xhold818 _3000_/X VDD VSS _4427_/D sg13g2_dlygate4sd3_1
Xhold807 _3972_/Y VDD VSS hold807/X sg13g2_dlygate4sd3_1
XFILLER_109_790 VDD VSS sg13g2_decap_8
Xhold829 _4372_/Q VDD VSS hold829/X sg13g2_dlygate4sd3_1
X_3461_ _3483_/B _3477_/C _3461_/A _3461_/Y VDD VSS sg13g2_nand3_1
X_3392_ VSS VDD _3362_/A _3391_/Y _3422_/S _3423_/B sg13g2_a21oi_1
X_2412_ _4921_/Q _4920_/Q _2412_/C _2412_/D _2814_/B VDD VSS sg13g2_and4_1
XFILLER_69_313 VDD VSS sg13g2_decap_8
X_4457__469 VDD VSS _4457_/RESET_B sg13g2_tiehi
X_2343_ VDD _3987_/B _2343_/A VSS sg13g2_inv_1
XFILLER_111_443 VDD VSS sg13g2_decap_8
Xhold1507 _2646_/Y VDD VSS _2647_/A sg13g2_dlygate4sd3_1
XFILLER_85_806 VDD VSS sg13g2_decap_8
XFILLER_111_476 VDD VSS sg13g2_decap_8
XFILLER_78_891 VDD VSS sg13g2_fill_1
XFILLER_84_327 VDD VSS sg13g2_decap_8
Xhold1518 _4637_/Q VDD VSS _3357_/C sg13g2_dlygate4sd3_1
Xhold1529 _3158_/Y VDD VSS _3159_/A2 sg13g2_dlygate4sd3_1
X_4013_ _4361_/Q _4386_/Q _4186_/S _4013_/X VDD VSS sg13g2_mux2_1
X_2274_ VDD _2274_/Y _3437_/A VSS sg13g2_inv_1
XFILLER_97_688 VDD VSS sg13g2_decap_8
XFILLER_84_349 VDD VSS sg13g2_decap_8
XFILLER_25_416 VDD VSS sg13g2_fill_1
XFILLER_26_917 VDD VSS sg13g2_decap_8
XFILLER_37_265 VDD VSS sg13g2_decap_8
XFILLER_65_563 VDD VSS sg13g2_decap_8
XFILLER_52_213 VDD VSS sg13g2_fill_2
Xclkbuf_leaf_17_clk clkbuf_4_7_0_clk/X _4601_/CLK VDD VSS sg13g2_buf_8
XFILLER_21_600 VDD VSS sg13g2_fill_1
XFILLER_33_460 VDD VSS sg13g2_decap_8
X_4915_ fanout261/X VSS VDD _4915_/D _4915_/Q clkload7/A sg13g2_dfrbpq_1
XFILLER_32_28 VDD VSS sg13g2_decap_4
X_4846_ fanout328/X VSS VDD _4846_/D _4846_/Q _4955_/CLK sg13g2_dfrbpq_1
XFILLER_21_677 VDD VSS sg13g2_decap_8
XFILLER_20_187 VDD VSS sg13g2_decap_8
XFILLER_20_198 VDD VSS sg13g2_fill_2
X_4777_ fanout259/X VSS VDD _4777_/D _4777_/Q _4907_/CLK sg13g2_dfrbpq_1
X_3728_ _3789_/B _3728_/C _3728_/A _3753_/A VDD VSS sg13g2_nand3_1
XFILLER_106_248 VDD VSS sg13g2_decap_8
X_3659_ _3659_/A _3639_/X _3659_/Y VDD VSS sg13g2_nor2b_1
XFILLER_0_515 VDD VSS sg13g2_decap_8
XFILLER_114_281 VDD VSS sg13g2_fill_1
XFILLER_57_14 VDD VSS sg13g2_decap_8
XFILLER_87_121 VDD VSS sg13g2_decap_8
XFILLER_29_722 VDD VSS sg13g2_decap_8
XFILLER_87_187 VDD VSS sg13g2_fill_2
XFILLER_28_265 VDD VSS sg13g2_decap_8
XFILLER_56_574 VDD VSS sg13g2_decap_8
XFILLER_71_500 VDD VSS sg13g2_decap_8
XFILLER_84_861 VDD VSS sg13g2_decap_8
XFILLER_71_522 VDD VSS sg13g2_decap_8
XFILLER_73_35 VDD VSS sg13g2_decap_8
XFILLER_83_371 VDD VSS sg13g2_decap_8
XFILLER_12_611 VDD VSS sg13g2_fill_2
XFILLER_12_622 VDD VSS sg13g2_decap_4
XFILLER_52_780 VDD VSS sg13g2_decap_8
XFILLER_11_165 VDD VSS sg13g2_decap_8
XFILLER_12_677 VDD VSS sg13g2_decap_8
XFILLER_12_688 VDD VSS sg13g2_fill_2
XFILLER_7_103 VDD VSS sg13g2_decap_8
X_4265__461 VDD VSS _4265_/RESET_B sg13g2_tiehi
XFILLER_8_626 VDD VSS sg13g2_decap_8
XFILLER_112_207 VDD VSS sg13g2_decap_8
XFILLER_4_865 VDD VSS sg13g2_decap_8
XFILLER_105_270 VDD VSS sg13g2_decap_4
XFILLER_79_611 VDD VSS sg13g2_decap_4
XFILLER_78_143 VDD VSS sg13g2_decap_8
XFILLER_67_828 VDD VSS sg13g2_decap_8
XFILLER_78_187 VDD VSS sg13g2_decap_8
XFILLER_93_102 VDD VSS sg13g2_decap_8
XFILLER_14_7 VDD VSS sg13g2_decap_8
XFILLER_47_530 VDD VSS sg13g2_decap_4
X_4272__454 VDD VSS _4272_/RESET_B sg13g2_tiehi
XFILLER_94_647 VDD VSS sg13g2_decap_8
XFILLER_35_703 VDD VSS sg13g2_fill_2
XFILLER_62_500 VDD VSS sg13g2_decap_8
XFILLER_81_319 VDD VSS sg13g2_fill_1
XFILLER_74_393 VDD VSS sg13g2_decap_4
XFILLER_15_471 VDD VSS sg13g2_decap_8
X_2961_ _4053_/A2 _3090_/A0 _2981_/S _2961_/X VDD VSS sg13g2_mux2_1
X_4700_ fanout323/X VSS VDD _4700_/D _4700_/Q _4972_/CLK sg13g2_dfrbpq_1
X_4631_ fanout265/X VSS VDD _4631_/D _4631_/Q _4658_/CLK sg13g2_dfrbpq_1
X_2892_ hold932/X _3100_/A0 _2900_/S _2892_/X VDD VSS sg13g2_mux2_1
XFILLER_8_63 VDD VSS sg13g2_decap_4
X_4562_ fanout317/X VSS VDD _4562_/D _4562_/Q _4929_/CLK sg13g2_dfrbpq_1
Xhold604 _4938_/Q VDD VSS _2759_/A sg13g2_dlygate4sd3_1
Xhold615 _3678_/Y VDD VSS _4750_/D sg13g2_dlygate4sd3_1
Xhold626 _4979_/Q VDD VSS _4255_/B sg13g2_dlygate4sd3_1
X_4493_ _2849_/C VSS VDD _4493_/D _4493_/Q _4527_/CLK sg13g2_dfrbpq_1
X_3513_ _3513_/Y _3513_/A _3513_/B VDD VSS sg13g2_nand2_1
Xclkbuf_leaf_6_clk clkbuf_4_3_0_clk/X clkload8/A VDD VSS sg13g2_buf_8
Xhold659 _4956_/Q VDD VSS _4026_/B sg13g2_dlygate4sd3_1
Xhold648 _4872_/Q VDD VSS _2540_/B sg13g2_dlygate4sd3_1
Xhold637 _2569_/X VDD VSS _4887_/D sg13g2_dlygate4sd3_1
X_3444_ _3443_/Y VDD _3444_/Y VSS _2261_/Y _3444_/A2 sg13g2_o21ai_1
XFILLER_40_0 VDD VSS sg13g2_decap_8
X_3375_ _4775_/Q _3393_/C _3495_/A VDD VSS sg13g2_nor2_1
XFILLER_97_441 VDD VSS sg13g2_decap_8
XFILLER_100_925 VDD VSS sg13g2_fill_1
XFILLER_111_273 VDD VSS sg13g2_decap_8
XFILLER_69_165 VDD VSS sg13g2_decap_8
Xhold1304 _4666_/Q VDD VSS _3455_/A sg13g2_dlygate4sd3_1
Xhold1315 _4604_/Q VDD VSS _2607_/C sg13g2_dlygate4sd3_1
X_2326_ VDD _2326_/Y _2326_/A VSS sg13g2_inv_1
XFILLER_85_614 VDD VSS sg13g2_decap_8
Xhold1326 _3474_/Y VDD VSS _4674_/D sg13g2_dlygate4sd3_1
Xhold1337 _4917_/Q VDD VSS _2806_/A sg13g2_dlygate4sd3_1
Xhold1348 _4657_/Q VDD VSS _3437_/A sg13g2_dlygate4sd3_1
Xhold1359 _2731_/Y VDD VSS _4946_/D sg13g2_dlygate4sd3_1
X_2257_ VDD _2508_/A _3160_/B VSS sg13g2_inv_1
XFILLER_38_541 VDD VSS sg13g2_fill_1
XFILLER_25_202 VDD VSS sg13g2_fill_2
XFILLER_26_747 VDD VSS sg13g2_fill_1
XFILLER_53_533 VDD VSS sg13g2_decap_8
XFILLER_81_842 VDD VSS sg13g2_decap_8
X_4388__338 VDD VSS _4388_/RESET_B sg13g2_tiehi
XFILLER_25_257 VDD VSS sg13g2_fill_1
XFILLER_80_352 VDD VSS sg13g2_decap_8
XFILLER_41_717 VDD VSS sg13g2_decap_8
X_4829_ fanout275/X VSS VDD _4829_/D _4829_/Q _4954_/CLK sg13g2_dfrbpq_1
XFILLER_107_513 VDD VSS sg13g2_decap_8
XFILLER_5_629 VDD VSS sg13g2_decap_8
XFILLER_4_117 VDD VSS sg13g2_fill_2
XFILLER_107_557 VDD VSS sg13g2_decap_8
XFILLER_0_312 VDD VSS sg13g2_decap_8
XFILLER_1_824 VDD VSS sg13g2_decap_8
XFILLER_103_752 VDD VSS sg13g2_decap_8
XFILLER_68_46 VDD VSS sg13g2_decap_8
XFILLER_0_389 VDD VSS sg13g2_decap_8
XFILLER_76_614 VDD VSS sg13g2_decap_4
XFILLER_29_530 VDD VSS sg13g2_decap_8
XFILLER_75_135 VDD VSS sg13g2_decap_8
XFILLER_76_658 VDD VSS sg13g2_decap_8
XFILLER_57_872 VDD VSS sg13g2_decap_8
XFILLER_63_308 VDD VSS sg13g2_decap_8
XFILLER_91_617 VDD VSS sg13g2_decap_8
XFILLER_29_596 VDD VSS sg13g2_decap_8
XFILLER_56_382 VDD VSS sg13g2_decap_8
XFILLER_84_680 VDD VSS sg13g2_decap_8
XFILLER_16_246 VDD VSS sg13g2_decap_8
XFILLER_44_544 VDD VSS sg13g2_decap_8
XFILLER_31_205 VDD VSS sg13g2_decap_8
X_4447__479 VDD VSS _4447_/RESET_B sg13g2_tiehi
XFILLER_40_772 VDD VSS sg13g2_decap_8
XFILLER_8_412 VDD VSS sg13g2_decap_8
XFILLER_113_505 VDD VSS sg13g2_fill_1
XFILLER_79_463 VDD VSS sg13g2_decap_8
X_3160_ _3160_/Y _3160_/B _2508_/D VDD VSS sg13g2_nand2b_1
XFILLER_55_809 VDD VSS sg13g2_decap_8
X_3091_ _3091_/A0 _3116_/A1 _3108_/S _4515_/D VDD VSS sg13g2_mux2_1
XFILLER_48_850 VDD VSS sg13g2_decap_8
XFILLER_66_146 VDD VSS sg13g2_fill_1
XFILLER_35_522 VDD VSS sg13g2_decap_8
XFILLER_63_831 VDD VSS sg13g2_decap_4
XFILLER_75_680 VDD VSS sg13g2_fill_2
XFILLER_75_691 VDD VSS sg13g2_decap_8
XFILLER_35_544 VDD VSS sg13g2_fill_1
XFILLER_81_149 VDD VSS sg13g2_decap_8
XFILLER_35_577 VDD VSS sg13g2_decap_8
XFILLER_35_588 VDD VSS sg13g2_fill_2
XFILLER_50_525 VDD VSS sg13g2_decap_8
XFILLER_62_374 VDD VSS sg13g2_decap_8
XFILLER_22_227 VDD VSS sg13g2_decap_8
X_3993_ _3993_/Y _3993_/A _4003_/B VDD VSS sg13g2_nand2_1
XFILLER_31_761 VDD VSS sg13g2_decap_8
X_2944_ hold936/X _3023_/A1 _2953_/S _2944_/X VDD VSS sg13g2_mux2_1
XFILLER_88_0 VDD VSS sg13g2_decap_8
X_2875_ _2875_/A0 _3110_/A0 _2875_/S _2875_/X VDD VSS sg13g2_mux2_1
X_4614_ fanout282/X VSS VDD _4614_/D _4614_/Q _4619_/CLK sg13g2_dfrbpq_1
XFILLER_116_310 VDD VSS sg13g2_decap_8
X_4545_ fanout286/X VSS VDD _4545_/D _4545_/Q _4552_/CLK sg13g2_dfrbpq_1
XFILLER_116_387 VDD VSS sg13g2_decap_8
X_4476_ fanout308/X VSS VDD _4476_/D _4476_/Q _4894_/CLK sg13g2_dfrbpq_1
X_3427_ _3471_/B _3443_/C _4652_/Q _3427_/Y VDD VSS sg13g2_nand3_1
XFILLER_100_711 VDD VSS sg13g2_decap_8
X_3358_ _3360_/B _3360_/C _3469_/C _3361_/B VDD VSS sg13g2_nand3_1
XFILLER_100_733 VDD VSS sg13g2_fill_1
XFILLER_38_49 VDD VSS sg13g2_decap_8
XFILLER_58_636 VDD VSS sg13g2_decap_8
Xhold1101 _2913_/X VDD VSS _4345_/D sg13g2_dlygate4sd3_1
Xhold1112 _2833_/X VDD VSS _4270_/D sg13g2_dlygate4sd3_1
Xhold1123 _4423_/Q VDD VSS _2996_/A0 sg13g2_dlygate4sd3_1
X_2309_ VDD _2774_/A _2759_/A VSS sg13g2_inv_1
XFILLER_85_422 VDD VSS sg13g2_decap_8
XFILLER_100_755 VDD VSS sg13g2_decap_8
Xhold1134 _4642_/Q VDD VSS _3649_/A sg13g2_dlygate4sd3_1
Xhold1145 _4519_/Q VDD VSS hold1145/X sg13g2_dlygate4sd3_1
Xhold1156 _4303_/Q VDD VSS _2868_/A0 sg13g2_dlygate4sd3_1
Xhold1167 _4273_/Q VDD VSS _2836_/A0 sg13g2_dlygate4sd3_1
X_3289_ _3289_/A _3289_/B _4621_/D VDD VSS sg13g2_nor2_1
XFILLER_38_360 VDD VSS sg13g2_fill_1
XFILLER_72_116 VDD VSS sg13g2_decap_8
Xhold1178 _4261_/Q VDD VSS _2824_/A0 sg13g2_dlygate4sd3_1
Xhold1189 _4441_/Q VDD VSS _3015_/A0 sg13g2_dlygate4sd3_1
XFILLER_14_706 VDD VSS sg13g2_decap_8
XFILLER_53_341 VDD VSS sg13g2_decap_8
XFILLER_14_739 VDD VSS sg13g2_decap_4
XFILLER_80_160 VDD VSS sg13g2_decap_4
XFILLER_81_672 VDD VSS sg13g2_fill_1
XFILLER_110_21 VDD VSS sg13g2_decap_8
XFILLER_10_923 VDD VSS sg13g2_fill_2
XFILLER_110_98 VDD VSS sg13g2_decap_8
XFILLER_70_58 VDD VSS sg13g2_decap_4
XFILLER_107_321 VDD VSS sg13g2_decap_8
XFILLER_108_822 VDD VSS sg13g2_decap_8
XFILLER_5_437 VDD VSS sg13g2_fill_2
X_4262__464 VDD VSS _4262_/RESET_B sg13g2_tiehi
XFILLER_107_343 VDD VSS sg13g2_fill_2
XFILLER_107_354 VDD VSS sg13g2_fill_1
XFILLER_1_632 VDD VSS sg13g2_decap_4
Xhold990 _4425_/Q VDD VSS hold990/X sg13g2_dlygate4sd3_1
XFILLER_103_560 VDD VSS sg13g2_decap_8
XFILLER_1_654 VDD VSS sg13g2_fill_2
XFILLER_95_208 VDD VSS sg13g2_decap_8
XFILLER_0_175 VDD VSS sg13g2_decap_8
XFILLER_1_698 VDD VSS sg13g2_decap_8
XFILLER_49_636 VDD VSS sg13g2_decap_8
XFILLER_76_422 VDD VSS sg13g2_fill_1
XFILLER_76_433 VDD VSS sg13g2_decap_8
XFILLER_89_794 VDD VSS sg13g2_decap_8
XFILLER_36_308 VDD VSS sg13g2_decap_8
XFILLER_48_146 VDD VSS sg13g2_fill_2
XFILLER_92_915 VDD VSS sg13g2_decap_8
XFILLER_17_522 VDD VSS sg13g2_decap_8
XFILLER_28_93 VDD VSS sg13g2_decap_8
XFILLER_36_319 VDD VSS sg13g2_fill_2
XFILLER_76_499 VDD VSS sg13g2_decap_8
XFILLER_91_436 VDD VSS sg13g2_decap_8
XFILLER_72_650 VDD VSS sg13g2_decap_8
XFILLER_32_514 VDD VSS sg13g2_decap_8
XFILLER_44_70 VDD VSS sg13g2_decap_8
XFILLER_32_569 VDD VSS sg13g2_decap_8
XFILLER_60_878 VDD VSS sg13g2_decap_4
XFILLER_9_710 VDD VSS sg13g2_fill_1
XFILLER_81_7 VDD VSS sg13g2_decap_8
XFILLER_12_282 VDD VSS sg13g2_fill_2
X_2660_ _2660_/B _2660_/C _2678_/A _2660_/Y VDD VSS sg13g2_nand3_1
XFILLER_9_776 VDD VSS sg13g2_fill_2
X_2591_ _3206_/B _2592_/B _3204_/B VDD VSS sg13g2_nand2_1
XFILLER_5_64 VDD VSS sg13g2_decap_8
X_4378__348 VDD VSS _4378_/RESET_B sg13g2_tiehi
X_4330_ _4330_/RESET_B VSS VDD _4330_/D _4330_/Q _4966_/CLK sg13g2_dfrbpq_1
XFILLER_113_324 VDD VSS sg13g2_fill_2
X_4261_ _4261_/RESET_B VSS VDD _4261_/D _4261_/Q _4527_/CLK sg13g2_dfrbpq_1
XFILLER_99_558 VDD VSS sg13g2_decap_8
X_3212_ _3230_/A _3212_/B _4589_/D VDD VSS sg13g2_nor2_1
XFILLER_39_124 VDD VSS sg13g2_decap_8
XFILLER_67_433 VDD VSS sg13g2_decap_8
X_4192_ _4192_/Y _4192_/B _4930_/D VDD VSS sg13g2_nand2b_1
X_3143_ _3142_/Y VDD _3143_/Y VSS _4632_/Q _3142_/B sg13g2_o21ai_1
XFILLER_55_639 VDD VSS sg13g2_decap_8
X_3074_ _4148_/B _3074_/A1 _3083_/S _4498_/D VDD VSS sg13g2_mux2_1
XFILLER_70_609 VDD VSS sg13g2_decap_8
XFILLER_23_514 VDD VSS sg13g2_decap_4
XFILLER_36_886 VDD VSS sg13g2_decap_8
XFILLER_51_801 VDD VSS sg13g2_decap_8
XFILLER_50_311 VDD VSS sg13g2_fill_1
XFILLER_62_193 VDD VSS sg13g2_decap_8
XFILLER_63_694 VDD VSS sg13g2_decap_8
X_3976_ _3976_/Y _3976_/B _2459_/Y VDD VSS sg13g2_nand2b_1
XFILLER_10_208 VDD VSS sg13g2_fill_1
X_2927_ _2927_/A0 _3109_/A0 _2927_/S _2927_/X VDD VSS sg13g2_mux2_1
X_2858_ _2858_/A0 _3017_/A1 _2873_/S _4293_/D VDD VSS sg13g2_mux2_1
XFILLER_3_919 VDD VSS sg13g2_decap_8
X_2789_ _2789_/A _2789_/B _4868_/D VDD VSS sg13g2_and2_1
XFILLER_116_151 VDD VSS sg13g2_decap_8
XFILLER_2_429 VDD VSS sg13g2_decap_8
X_4528_ fanout286/X VSS VDD _4528_/D _4528_/Q _4927_/CLK sg13g2_dfrbpq_1
X_4459_ _4459_/RESET_B VSS VDD _4459_/D _4459_/Q _4967_/CLK sg13g2_dfrbpq_1
XFILLER_104_379 VDD VSS sg13g2_decap_8
XFILLER_77_208 VDD VSS sg13g2_decap_8
X_4437__489 VDD VSS _4437_/RESET_B sg13g2_tiehi
XFILLER_98_591 VDD VSS sg13g2_decap_8
XFILLER_86_720 VDD VSS sg13g2_fill_1
XFILLER_100_552 VDD VSS sg13g2_decap_8
XFILLER_18_308 VDD VSS sg13g2_fill_2
XFILLER_65_14 VDD VSS sg13g2_decap_8
XFILLER_45_116 VDD VSS sg13g2_decap_8
XFILLER_46_639 VDD VSS sg13g2_decap_4
XFILLER_58_488 VDD VSS sg13g2_decap_8
XFILLER_85_263 VDD VSS sg13g2_fill_2
XFILLER_26_374 VDD VSS sg13g2_decap_8
XFILLER_14_558 VDD VSS sg13g2_decap_8
XFILLER_41_355 VDD VSS sg13g2_decap_8
XFILLER_41_366 VDD VSS sg13g2_fill_1
XFILLER_42_878 VDD VSS sg13g2_decap_8
XFILLER_42_889 VDD VSS sg13g2_fill_1
XFILLER_41_377 VDD VSS sg13g2_decap_8
XFILLER_22_591 VDD VSS sg13g2_decap_8
XFILLER_6_735 VDD VSS sg13g2_decap_8
XFILLER_5_223 VDD VSS sg13g2_decap_8
XFILLER_30_83 VDD VSS sg13g2_decap_8
XFILLER_111_828 VDD VSS sg13g2_fill_2
XFILLER_110_349 VDD VSS sg13g2_fill_2
XFILLER_39_92 VDD VSS sg13g2_decap_4
XFILLER_65_904 VDD VSS sg13g2_decap_8
XFILLER_37_639 VDD VSS sg13g2_decap_8
XFILLER_76_263 VDD VSS sg13g2_decap_8
XFILLER_77_797 VDD VSS sg13g2_decap_8
XFILLER_36_127 VDD VSS sg13g2_decap_4
XFILLER_64_436 VDD VSS sg13g2_decap_8
XFILLER_92_756 VDD VSS sg13g2_decap_8
XFILLER_33_856 VDD VSS sg13g2_decap_8
XFILLER_44_171 VDD VSS sg13g2_decap_8
X_3830_ _3830_/Y _3848_/A _3830_/B VDD VSS sg13g2_nand2_1
X_3761_ _3761_/Y _3765_/B _3761_/B VDD VSS sg13g2_nand2_1
X_2712_ VSS VDD _3555_/A _3504_/B _2712_/Y _3506_/A sg13g2_a21oi_1
X_3692_ VSS VDD _2448_/B _3690_/Y _3692_/Y _3691_/Y sg13g2_a21oi_1
X_2643_ _3677_/B _4858_/Q _4004_/A VDD VSS sg13g2_nand2b_1
X_2574_ _2576_/C _2576_/A _2574_/X VDD VSS sg13g2_xor2_1
X_4313_ _4313_/RESET_B VSS VDD _4313_/D _4313_/Q _4926_/CLK sg13g2_dfrbpq_1
XFILLER_102_817 VDD VSS sg13g2_fill_1
XFILLER_102_828 VDD VSS sg13g2_decap_8
XFILLER_113_154 VDD VSS sg13g2_decap_8
XFILLER_101_316 VDD VSS sg13g2_decap_8
X_4244_ VSS VDD _4244_/A1 _4242_/X _4244_/Y _4243_/Y sg13g2_a21oi_1
XFILLER_28_606 VDD VSS sg13g2_decap_8
XFILLER_67_241 VDD VSS sg13g2_decap_4
X_4175_ _4175_/A0 _4175_/A1 _4240_/A _4175_/X VDD VSS sg13g2_mux2_1
XFILLER_27_116 VDD VSS sg13g2_decap_8
X_3126_ _4631_/Q hold874/X _3142_/B _3126_/X VDD VSS sg13g2_mux2_1
XFILLER_27_127 VDD VSS sg13g2_fill_1
XFILLER_83_745 VDD VSS sg13g2_fill_2
XFILLER_43_609 VDD VSS sg13g2_decap_8
XFILLER_55_469 VDD VSS sg13g2_decap_8
XFILLER_70_406 VDD VSS sg13g2_fill_2
XFILLER_70_417 VDD VSS sg13g2_decap_8
XFILLER_82_255 VDD VSS sg13g2_decap_8
XFILLER_83_778 VDD VSS sg13g2_decap_8
X_3057_ _3544_/A1 _3084_/A1 _3057_/S _4483_/D VDD VSS sg13g2_mux2_1
XFILLER_24_823 VDD VSS sg13g2_fill_1
XFILLER_24_834 VDD VSS sg13g2_fill_1
XFILLER_36_683 VDD VSS sg13g2_decap_8
XFILLER_51_675 VDD VSS sg13g2_decap_8
X_3959_ _3959_/Y _3959_/B _2481_/C VDD VSS sg13g2_nand2b_1
XFILLER_3_716 VDD VSS sg13g2_decap_8
XFILLER_2_226 VDD VSS sg13g2_fill_2
XFILLER_2_237 VDD VSS sg13g2_fill_2
XFILLER_105_688 VDD VSS sg13g2_decap_8
XFILLER_116_42 VDD VSS sg13g2_decap_8
XFILLER_58_241 VDD VSS sg13g2_decap_4
XFILLER_86_550 VDD VSS sg13g2_fill_2
XFILLER_101_872 VDD VSS sg13g2_decap_8
XFILLER_101_883 VDD VSS sg13g2_fill_1
XFILLER_19_617 VDD VSS sg13g2_decap_8
XFILLER_59_797 VDD VSS sg13g2_decap_8
XFILLER_74_734 VDD VSS sg13g2_decap_8
XFILLER_73_233 VDD VSS sg13g2_decap_8
XFILLER_27_661 VDD VSS sg13g2_decap_8
XFILLER_61_406 VDD VSS sg13g2_decap_8
XFILLER_62_918 VDD VSS sg13g2_decap_8
XFILLER_26_182 VDD VSS sg13g2_decap_8
XFILLER_92_56 VDD VSS sg13g2_decap_8
XFILLER_14_333 VDD VSS sg13g2_decap_8
XFILLER_42_653 VDD VSS sg13g2_decap_8
X_4368__358 VDD VSS _4368_/RESET_B sg13g2_tiehi
XFILLER_30_815 VDD VSS sg13g2_decap_8
XFILLER_41_163 VDD VSS sg13g2_decap_8
XFILLER_6_510 VDD VSS sg13g2_decap_8
XFILLER_41_82 VDD VSS sg13g2_decap_8
XFILLER_44_7 VDD VSS sg13g2_decap_8
XFILLER_6_598 VDD VSS sg13g2_fill_2
XFILLER_111_636 VDD VSS sg13g2_decap_8
XFILLER_2_771 VDD VSS sg13g2_decap_8
X_2290_ VDD _2290_/Y _3469_/A VSS sg13g2_inv_1
XFILLER_2_21 VDD VSS sg13g2_decap_8
XFILLER_65_745 VDD VSS sg13g2_fill_1
XFILLER_53_918 VDD VSS sg13g2_decap_8
XFILLER_80_737 VDD VSS sg13g2_decap_8
X_4931_ fanout319/X VSS VDD _4931_/D _4931_/Q _4931_/CLK sg13g2_dfrbpq_1
XFILLER_17_193 VDD VSS sg13g2_decap_4
XFILLER_33_653 VDD VSS sg13g2_fill_1
X_4862_ fanout335/X VSS VDD _4862_/D _4862_/Q _4933_/CLK sg13g2_dfrbpq_1
XFILLER_20_314 VDD VSS sg13g2_decap_8
XFILLER_21_826 VDD VSS sg13g2_fill_1
X_3813_ _3813_/Y _3837_/B1 _3812_/Y _3837_/A2 _2326_/Y VDD VSS sg13g2_a22oi_1
XFILLER_32_196 VDD VSS sg13g2_decap_8
X_4793_ fanout247/X VSS VDD _4793_/D _4793_/Q _4904_/CLK sg13g2_dfrbpq_1
XFILLER_70_0 VDD VSS sg13g2_decap_8
X_4427__499 VDD VSS _4427_/RESET_B sg13g2_tiehi
X_3744_ _3742_/Y VDD _4761_/D VSS _3766_/A1 _3743_/Y sg13g2_o21ai_1
X_3675_ _3719_/A VDD _3675_/Y VSS _3700_/C _3674_/X sg13g2_o21ai_1
X_2626_ VDD _4902_/D _3791_/S VSS sg13g2_inv_1
X_2557_ VSS VDD _4881_/Q _2556_/C _2557_/Y _2556_/B sg13g2_a21oi_1
XFILLER_88_815 VDD VSS sg13g2_decap_8
XFILLER_87_303 VDD VSS sg13g2_fill_2
X_2488_ _3866_/B _2488_/A _2488_/B _2641_/B VDD VSS sg13g2_and3_1
XFILLER_99_196 VDD VSS sg13g2_decap_8
XFILLER_87_336 VDD VSS sg13g2_fill_2
XFILLER_101_124 VDD VSS sg13g2_decap_8
XFILLER_29_904 VDD VSS sg13g2_decap_8
XFILLER_68_550 VDD VSS sg13g2_decap_8
X_4227_ _4227_/B1 VDD _4227_/Y VSS _4227_/A1 _4226_/X sg13g2_o21ai_1
XFILLER_101_179 VDD VSS sg13g2_decap_8
X_4158_ _4157_/Y VDD _4158_/Y VSS _4154_/Y _4156_/Y sg13g2_o21ai_1
XFILLER_28_469 VDD VSS sg13g2_decap_8
XFILLER_43_417 VDD VSS sg13g2_decap_8
X_4089_ _4088_/Y VDD _4089_/Y VSS _4086_/Y _4087_/Y sg13g2_o21ai_1
X_3109_ _3109_/A0 _3140_/A _3109_/S _4533_/D VDD VSS sg13g2_mux2_1
XFILLER_55_288 VDD VSS sg13g2_decap_8
XFILLER_70_203 VDD VSS sg13g2_decap_8
XFILLER_102_77 VDD VSS sg13g2_decap_8
XFILLER_11_303 VDD VSS sg13g2_decap_4
XFILLER_23_163 VDD VSS sg13g2_fill_2
XFILLER_24_697 VDD VSS sg13g2_decap_8
XFILLER_23_185 VDD VSS sg13g2_decap_4
XFILLER_20_870 VDD VSS sg13g2_decap_8
XFILLER_109_246 VDD VSS sg13g2_fill_1
XFILLER_11_41 VDD VSS sg13g2_decap_8
XFILLER_79_826 VDD VSS sg13g2_decap_8
XFILLER_87_67 VDD VSS sg13g2_decap_8
XFILLER_94_807 VDD VSS sg13g2_decap_8
XFILLER_87_881 VDD VSS sg13g2_fill_1
XFILLER_87_870 VDD VSS sg13g2_decap_8
XFILLER_15_620 VDD VSS sg13g2_decap_4
XFILLER_36_71 VDD VSS sg13g2_decap_8
XFILLER_62_737 VDD VSS sg13g2_decap_8
XFILLER_30_612 VDD VSS sg13g2_decap_8
XFILLER_14_196 VDD VSS sg13g2_decap_4
XFILLER_30_667 VDD VSS sg13g2_decap_8
XFILLER_7_830 VDD VSS sg13g2_decap_8
XFILLER_116_717 VDD VSS sg13g2_decap_8
XFILLER_116_728 VDD VSS sg13g2_fill_1
Xhold819 _4424_/Q VDD VSS _4142_/B sg13g2_dlygate4sd3_1
Xhold808 _4501_/Q VDD VSS hold808/X sg13g2_dlygate4sd3_1
X_3460_ _3459_/Y VDD _4667_/D VSS _2278_/Y _3473_/C sg13g2_o21ai_1
XFILLER_112_912 VDD VSS sg13g2_decap_8
X_3391_ _3390_/Y VDD _3391_/Y VSS _3382_/Y _3388_/Y sg13g2_o21ai_1
X_2411_ _2419_/A _2425_/A _3407_/A _2411_/D _2412_/D VDD VSS sg13g2_nor4_1
X_2342_ VDD _3983_/B _2342_/A VSS sg13g2_inv_1
XFILLER_97_623 VDD VSS sg13g2_decap_8
XFILLER_111_455 VDD VSS sg13g2_decap_8
XFILLER_69_369 VDD VSS sg13g2_decap_8
Xhold1508 _4730_/Q VDD VSS _3618_/A0 sg13g2_dlygate4sd3_1
XFILLER_97_667 VDD VSS sg13g2_decap_8
XFILLER_78_870 VDD VSS sg13g2_decap_8
XFILLER_84_306 VDD VSS sg13g2_decap_8
Xhold1519 _4595_/Q VDD VSS _3224_/A sg13g2_dlygate4sd3_1
X_4012_ _4190_/A1 VDD _4012_/Y VSS _4196_/A1 _4436_/Q sg13g2_o21ai_1
X_2273_ VDD _2273_/Y _3453_/A VSS sg13g2_inv_1
XFILLER_37_222 VDD VSS sg13g2_decap_8
XFILLER_65_542 VDD VSS sg13g2_decap_8
XFILLER_77_380 VDD VSS sg13g2_decap_8
XFILLER_96_199 VDD VSS sg13g2_decap_8
XFILLER_93_840 VDD VSS sg13g2_fill_2
XFILLER_37_288 VDD VSS sg13g2_decap_8
XFILLER_52_225 VDD VSS sg13g2_decap_8
XFILLER_65_597 VDD VSS sg13g2_decap_8
XFILLER_80_534 VDD VSS sg13g2_decap_8
XFILLER_92_383 VDD VSS sg13g2_fill_2
XFILLER_52_236 VDD VSS sg13g2_fill_1
X_4914_ fanout261/X VSS VDD _4914_/D _4914_/Q clkload7/A sg13g2_dfrbpq_1
XFILLER_21_656 VDD VSS sg13g2_decap_8
X_4845_ fanout331/X VSS VDD _4845_/D _4845_/Q _4955_/CLK sg13g2_dfrbpq_1
X_4776_ fanout259/X VSS VDD _4776_/D _4776_/Q _4907_/CLK sg13g2_dfrbpq_1
X_3727_ _3726_/Y VDD _3727_/Y VSS _3722_/B _3725_/Y sg13g2_o21ai_1
XFILLER_107_706 VDD VSS sg13g2_decap_4
X_3658_ VSS VDD _4746_/Q _3717_/B _3659_/A _3657_/Y sg13g2_a21oi_1
XFILLER_115_761 VDD VSS sg13g2_decap_4
X_3589_ _3586_/Y VDD _3589_/Y VSS _3608_/A _3588_/Y sg13g2_o21ai_1
X_2609_ _2609_/B _2609_/C _2609_/A _3258_/B VDD VSS _3251_/B sg13g2_nand4_1
XFILLER_88_601 VDD VSS sg13g2_decap_8
XFILLER_115_772 VDD VSS sg13g2_decap_4
X_4358__368 VDD VSS _4358_/RESET_B sg13g2_tiehi
XFILLER_88_612 VDD VSS sg13g2_fill_2
XFILLER_87_100 VDD VSS sg13g2_decap_8
XFILLER_102_444 VDD VSS sg13g2_decap_4
XFILLER_29_701 VDD VSS sg13g2_decap_8
XFILLER_69_881 VDD VSS sg13g2_fill_2
XFILLER_75_328 VDD VSS sg13g2_decap_8
Xclkbuf_4_5_0_clk clkbuf_0_clk/X clkbuf_4_5_0_clk/X VDD VSS sg13g2_buf_8
XFILLER_87_166 VDD VSS sg13g2_decap_8
XFILLER_113_21 VDD VSS sg13g2_fill_2
XFILLER_56_531 VDD VSS sg13g2_decap_8
XFILLER_28_233 VDD VSS sg13g2_decap_8
XFILLER_28_244 VDD VSS sg13g2_decap_8
XFILLER_16_417 VDD VSS sg13g2_decap_8
XFILLER_44_726 VDD VSS sg13g2_decap_8
XFILLER_73_14 VDD VSS sg13g2_decap_8
XFILLER_43_236 VDD VSS sg13g2_decap_4
XFILLER_43_269 VDD VSS sg13g2_decap_8
XFILLER_71_589 VDD VSS sg13g2_decap_8
XFILLER_11_111 VDD VSS sg13g2_decap_8
XFILLER_12_645 VDD VSS sg13g2_decap_4
XFILLER_8_605 VDD VSS sg13g2_decap_8
XFILLER_11_199 VDD VSS sg13g2_decap_8
XFILLER_22_51 VDD VSS sg13g2_fill_1
XFILLER_22_95 VDD VSS sg13g2_decap_8
XFILLER_3_310 VDD VSS sg13g2_fill_2
XFILLER_4_844 VDD VSS sg13g2_decap_8
XFILLER_0_0 VDD VSS sg13g2_decap_8
XFILLER_78_100 VDD VSS sg13g2_decap_8
XFILLER_67_807 VDD VSS sg13g2_decap_8
X_4456__470 VDD VSS _4456_/RESET_B sg13g2_tiehi
XFILLER_78_166 VDD VSS sg13g2_decap_8
XFILLER_66_339 VDD VSS sg13g2_decap_8
Xfanout190 _4144_/S _4038_/A VDD VSS sg13g2_buf_1
XFILLER_93_136 VDD VSS sg13g2_decap_4
XFILLER_19_244 VDD VSS sg13g2_decap_8
XFILLER_75_862 VDD VSS sg13g2_fill_2
XFILLER_19_299 VDD VSS sg13g2_decap_8
XFILLER_34_203 VDD VSS sg13g2_decap_8
XFILLER_35_748 VDD VSS sg13g2_decap_8
XFILLER_90_821 VDD VSS sg13g2_decap_8
XFILLER_62_545 VDD VSS sg13g2_decap_8
XFILLER_15_450 VDD VSS sg13g2_decap_8
XFILLER_43_781 VDD VSS sg13g2_decap_8
XFILLER_50_729 VDD VSS sg13g2_decap_8
X_2960_ _2960_/A0 _3089_/A0 _2979_/S _2960_/X VDD VSS sg13g2_mux2_1
XFILLER_90_887 VDD VSS sg13g2_decap_4
X_2891_ hold979/X _3023_/A1 _2900_/S _2891_/X VDD VSS sg13g2_mux2_1
X_4630_ fanout263/X VSS VDD _4630_/D _4630_/Q _4673_/CLK sg13g2_dfrbpq_1
XFILLER_8_42 VDD VSS sg13g2_decap_8
X_4561_ fanout317/X VSS VDD _4561_/D _4561_/Q _4931_/CLK sg13g2_dfrbpq_1
XFILLER_116_547 VDD VSS sg13g2_decap_8
Xhold605 _2776_/Y VDD VSS _4938_/D sg13g2_dlygate4sd3_1
Xhold616 _4922_/Q VDD VSS _2357_/A sg13g2_dlygate4sd3_1
Xhold627 _4256_/Y VDD VSS _4979_/D sg13g2_dlygate4sd3_1
X_4492_ fanout296/X VSS VDD _4492_/D _4492_/Q _4960_/CLK sg13g2_dfrbpq_1
X_3512_ _3510_/Y VDD _3512_/Y VSS _3504_/Y _3511_/Y sg13g2_o21ai_1
Xhold649 _4972_/Q VDD VSS _4192_/B sg13g2_dlygate4sd3_1
Xhold638 _4960_/Q VDD VSS _4066_/B sg13g2_dlygate4sd3_1
X_3443_ _3471_/B _3443_/C _3443_/A _3443_/Y VDD VSS sg13g2_nand3_1
XFILLER_98_921 VDD VSS sg13g2_fill_1
XFILLER_33_0 VDD VSS sg13g2_decap_8
XFILLER_58_807 VDD VSS sg13g2_decap_8
XFILLER_69_144 VDD VSS sg13g2_decap_8
X_3374_ _3373_/Y VDD _3374_/Y VSS _3307_/B _3493_/B sg13g2_o21ai_1
XFILLER_97_420 VDD VSS sg13g2_decap_8
XFILLER_100_904 VDD VSS sg13g2_decap_8
Xhold1305 _4908_/Q VDD VSS _2798_/A sg13g2_dlygate4sd3_1
Xhold1316 _3246_/Y VDD VSS _3248_/A1 sg13g2_dlygate4sd3_1
X_2325_ VDD _2325_/Y _2325_/A VSS sg13g2_inv_1
Xhold1327 _4473_/Q VDD VSS _3534_/A1 sg13g2_dlygate4sd3_1
Xhold1338 _2806_/Y VDD VSS _2807_/C sg13g2_dlygate4sd3_1
Xhold1349 _3438_/Y VDD VSS _4656_/D sg13g2_dlygate4sd3_1
X_2256_ VDD _2256_/Y _3555_/A VSS sg13g2_inv_1
XFILLER_97_497 VDD VSS sg13g2_decap_4
XFILLER_38_575 VDD VSS sg13g2_fill_1
XFILLER_66_884 VDD VSS sg13g2_decap_8
XFILLER_81_832 VDD VSS sg13g2_decap_4
XFILLER_92_180 VDD VSS sg13g2_decap_8
X_4828_ fanout270/X VSS VDD _4828_/D _4828_/Q _4841_/CLK sg13g2_dfrbpq_1
XFILLER_21_497 VDD VSS sg13g2_decap_8
X_4759_ fanout257/X VSS VDD _4759_/D _4759_/Q _4907_/CLK sg13g2_dfrbpq_1
XFILLER_107_536 VDD VSS sg13g2_decap_8
XFILLER_111_7 VDD VSS sg13g2_decap_8
XFILLER_1_803 VDD VSS sg13g2_decap_8
XFILLER_108_98 VDD VSS sg13g2_decap_4
XFILLER_115_591 VDD VSS sg13g2_decap_8
XFILLER_0_368 VDD VSS sg13g2_decap_8
XFILLER_49_829 VDD VSS sg13g2_decap_8
XFILLER_57_840 VDD VSS sg13g2_fill_1
XFILLER_75_114 VDD VSS sg13g2_decap_8
XFILLER_88_497 VDD VSS sg13g2_decap_8
XFILLER_57_851 VDD VSS sg13g2_decap_8
XFILLER_29_575 VDD VSS sg13g2_decap_8
XFILLER_44_512 VDD VSS sg13g2_decap_8
XFILLER_84_68 VDD VSS sg13g2_decap_8
XFILLER_16_225 VDD VSS sg13g2_decap_8
XFILLER_17_51 VDD VSS sg13g2_decap_8
XFILLER_72_854 VDD VSS sg13g2_decap_8
XFILLER_83_191 VDD VSS sg13g2_fill_1
XFILLER_13_910 VDD VSS sg13g2_decap_8
XFILLER_44_589 VDD VSS sg13g2_decap_8
XFILLER_72_887 VDD VSS sg13g2_decap_8
XFILLER_71_386 VDD VSS sg13g2_decap_8
XFILLER_71_397 VDD VSS sg13g2_fill_1
XFILLER_24_291 VDD VSS sg13g2_decap_8
XFILLER_98_217 VDD VSS sg13g2_fill_1
XFILLER_106_580 VDD VSS sg13g2_decap_8
XFILLER_79_442 VDD VSS sg13g2_decap_8
XFILLER_39_306 VDD VSS sg13g2_fill_1
XFILLER_66_136 VDD VSS sg13g2_fill_1
XFILLER_67_659 VDD VSS sg13g2_decap_8
X_3090_ _3090_/A0 _3115_/A1 _3104_/S _3090_/X VDD VSS sg13g2_mux2_1
XFILLER_63_810 VDD VSS sg13g2_decap_8
XFILLER_47_394 VDD VSS sg13g2_decap_8
XFILLER_62_331 VDD VSS sg13g2_decap_8
XFILLER_74_191 VDD VSS sg13g2_decap_8
XFILLER_16_770 VDD VSS sg13g2_decap_4
XFILLER_22_206 VDD VSS sg13g2_decap_8
XFILLER_50_504 VDD VSS sg13g2_decap_8
X_3992_ VSS VDD _3999_/A _3997_/A _3992_/Y _3991_/Y sg13g2_a21oi_1
X_2943_ _2943_/A0 _3098_/A0 _2954_/S _4373_/D VDD VSS sg13g2_mux2_1
X_4348__378 VDD VSS _4348_/RESET_B sg13g2_tiehi
X_2874_ _2874_/A0 _3109_/A0 _2874_/S _4309_/D VDD VSS sg13g2_mux2_1
X_4613_ fanout282/X VSS VDD _4613_/D _4613_/Q _4619_/CLK sg13g2_dfrbpq_1
X_4544_ fanout286/X VSS VDD _4544_/D _4544_/Q _4552_/CLK sg13g2_dfrbpq_1
XFILLER_116_366 VDD VSS sg13g2_decap_8
X_4475_ fanout325/X VSS VDD _4475_/D _4475_/Q _4868_/CLK sg13g2_dfrbpq_1
X_3426_ _3425_/Y _3422_/S _3423_/X _4649_/D VDD VSS sg13g2_a21o_1
XFILLER_58_615 VDD VSS sg13g2_decap_8
XFILLER_85_401 VDD VSS sg13g2_decap_8
X_3357_ _3360_/C _3357_/A _3357_/B _3357_/C VDD VSS sg13g2_and3_1
XFILLER_112_594 VDD VSS sg13g2_decap_8
XFILLER_38_28 VDD VSS sg13g2_decap_8
XFILLER_57_103 VDD VSS sg13g2_decap_4
Xhold1102 _4498_/Q VDD VSS _3074_/A1 sg13g2_dlygate4sd3_1
Xhold1113 _4539_/Q VDD VSS _3115_/A1 sg13g2_dlygate4sd3_1
Xhold1124 _4434_/Q VDD VSS _3007_/A0 sg13g2_dlygate4sd3_1
X_2308_ VDD _2308_/Y _4006_/A VSS sg13g2_inv_1
XFILLER_97_272 VDD VSS sg13g2_fill_2
XFILLER_57_147 VDD VSS sg13g2_fill_1
XFILLER_57_158 VDD VSS sg13g2_fill_2
Xhold1135 _4472_/Q VDD VSS _3533_/A1 sg13g2_dlygate4sd3_1
Xhold1146 _4278_/Q VDD VSS _2841_/A0 sg13g2_dlygate4sd3_1
Xhold1157 _2868_/X VDD VSS _4303_/D sg13g2_dlygate4sd3_1
X_3288_ VDD VSS _4621_/Q _3288_/C1 _3285_/Y _2618_/A _3288_/Y _3286_/B sg13g2_a221oi_1
XFILLER_85_478 VDD VSS sg13g2_decap_8
XFILLER_26_523 VDD VSS sg13g2_decap_8
Xhold1168 _4294_/Q VDD VSS _2859_/A0 sg13g2_dlygate4sd3_1
Xhold1179 _4402_/Q VDD VSS _4175_/A1 sg13g2_dlygate4sd3_1
X_2239_ VDD _3192_/A _3232_/A VSS sg13g2_inv_1
XFILLER_38_383 VDD VSS sg13g2_decap_8
XFILLER_53_320 VDD VSS sg13g2_decap_8
XFILLER_81_662 VDD VSS sg13g2_fill_1
XFILLER_81_684 VDD VSS sg13g2_decap_8
XFILLER_10_902 VDD VSS sg13g2_decap_8
XFILLER_110_77 VDD VSS sg13g2_decap_8
XFILLER_22_773 VDD VSS sg13g2_decap_4
X_4446__480 VDD VSS _4446_/RESET_B sg13g2_tiehi
XFILLER_108_801 VDD VSS sg13g2_decap_8
XFILLER_21_294 VDD VSS sg13g2_decap_8
XFILLER_6_917 VDD VSS sg13g2_decap_8
XFILLER_1_611 VDD VSS sg13g2_decap_8
Xhold980 _2891_/X VDD VSS _4324_/D sg13g2_dlygate4sd3_1
Xhold991 _2998_/X VDD VSS _4425_/D sg13g2_dlygate4sd3_1
XFILLER_0_154 VDD VSS sg13g2_decap_8
XFILLER_49_615 VDD VSS sg13g2_decap_8
XFILLER_76_401 VDD VSS sg13g2_decap_8
XFILLER_89_784 VDD VSS sg13g2_fill_1
XFILLER_48_136 VDD VSS sg13g2_decap_4
XFILLER_64_618 VDD VSS sg13g2_decap_4
X_4453__473 VDD VSS _4453_/RESET_B sg13g2_tiehi
XFILLER_95_89 VDD VSS sg13g2_decap_4
XFILLER_28_72 VDD VSS sg13g2_decap_8
XFILLER_45_821 VDD VSS sg13g2_decap_8
XFILLER_76_478 VDD VSS sg13g2_decap_8
Xhold1680 _4860_/Q VDD VSS _3522_/B sg13g2_dlygate4sd3_1
XFILLER_91_415 VDD VSS sg13g2_decap_8
XFILLER_32_548 VDD VSS sg13g2_decap_8
XFILLER_71_172 VDD VSS sg13g2_decap_8
XFILLER_74_7 VDD VSS sg13g2_decap_8
X_4460__466 VDD VSS _4460_/RESET_B sg13g2_tiehi
XFILLER_9_755 VDD VSS sg13g2_decap_8
XFILLER_8_287 VDD VSS sg13g2_decap_8
X_2590_ _2592_/A _3202_/B _3204_/B VDD VSS sg13g2_and2_1
XFILLER_114_815 VDD VSS sg13g2_decap_8
XFILLER_5_43 VDD VSS sg13g2_decap_8
XFILLER_99_537 VDD VSS sg13g2_decap_8
XFILLER_4_471 VDD VSS sg13g2_decap_8
X_4260_ fanout279/X VSS VDD _4260_/D _4260_/Q _4942_/CLK sg13g2_dfrbpq_1
X_4191_ _4191_/Y _4930_/D _4191_/B VDD VSS sg13g2_nand2_1
X_3211_ _3213_/B _3210_/Y _3212_/B VDD VSS sg13g2_nor2b_1
X_3142_ _3142_/Y _3142_/A _3142_/B VDD VSS sg13g2_nand2_1
XFILLER_95_721 VDD VSS sg13g2_decap_8
XFILLER_55_607 VDD VSS sg13g2_fill_1
X_3073_ _4139_/B hold854/X _3084_/S _4497_/D VDD VSS sg13g2_mux2_1
XFILLER_36_865 VDD VSS sg13g2_decap_8
XFILLER_62_161 VDD VSS sg13g2_decap_8
XFILLER_90_481 VDD VSS sg13g2_decap_8
XFILLER_51_879 VDD VSS sg13g2_fill_2
X_3975_ _4830_/D hold807/X _2337_/Y _3976_/B _2635_/Y VDD VSS sg13g2_a22oi_1
X_2926_ _2926_/A0 _3032_/A1 _2926_/S _2926_/X VDD VSS sg13g2_mux2_1
X_2857_ _2857_/A0 _3092_/A0 _2875_/S _4292_/D VDD VSS sg13g2_mux2_1
X_2788_ _2787_/B _2787_/A _2787_/C _2789_/B VDD VSS sg13g2_a21o_1
XFILLER_2_408 VDD VSS sg13g2_decap_8
X_4527_ fanout312/X VSS VDD _4527_/D _4527_/Q _4527_/CLK sg13g2_dfrbpq_1
XFILLER_105_859 VDD VSS sg13g2_decap_4
X_4458_ _4458_/RESET_B VSS VDD _4458_/D _4458_/Q _4966_/CLK sg13g2_dfrbpq_1
XFILLER_49_49 VDD VSS sg13g2_decap_8
XFILLER_59_913 VDD VSS sg13g2_decap_8
XFILLER_59_924 VDD VSS sg13g2_fill_2
X_3409_ _3409_/A0 _3408_/Y _3422_/S _4647_/D VDD VSS sg13g2_mux2_1
XFILLER_58_434 VDD VSS sg13g2_decap_8
X_4389_ _4389_/RESET_B VSS VDD _4389_/D _4389_/Q _4958_/CLK sg13g2_dfrbpq_1
XFILLER_98_570 VDD VSS sg13g2_decap_8
XFILLER_100_531 VDD VSS sg13g2_decap_8
XFILLER_58_445 VDD VSS sg13g2_fill_1
XFILLER_85_253 VDD VSS sg13g2_fill_1
XFILLER_105_77 VDD VSS sg13g2_decap_8
XFILLER_73_415 VDD VSS sg13g2_fill_1
XFILLER_73_426 VDD VSS sg13g2_decap_8
XFILLER_26_353 VDD VSS sg13g2_decap_8
XFILLER_60_109 VDD VSS sg13g2_decap_8
XFILLER_14_537 VDD VSS sg13g2_decap_8
XFILLER_42_857 VDD VSS sg13g2_decap_8
XFILLER_53_172 VDD VSS sg13g2_fill_2
XFILLER_54_695 VDD VSS sg13g2_fill_2
XFILLER_81_14 VDD VSS sg13g2_decap_8
XFILLER_41_334 VDD VSS sg13g2_decap_8
XFILLER_53_194 VDD VSS sg13g2_decap_8
XFILLER_14_85 VDD VSS sg13g2_decap_8
XFILLER_14_96 VDD VSS sg13g2_fill_1
XFILLER_10_765 VDD VSS sg13g2_decap_4
XFILLER_6_714 VDD VSS sg13g2_decap_8
XFILLER_100_0 VDD VSS sg13g2_decap_8
XFILLER_30_62 VDD VSS sg13g2_decap_8
XFILLER_107_174 VDD VSS sg13g2_decap_8
XFILLER_111_807 VDD VSS sg13g2_decap_8
XFILLER_68_209 VDD VSS sg13g2_decap_4
XFILLER_110_339 VDD VSS sg13g2_decap_4
XFILLER_103_380 VDD VSS sg13g2_decap_8
XFILLER_1_496 VDD VSS sg13g2_fill_1
XFILLER_39_71 VDD VSS sg13g2_decap_8
XFILLER_49_445 VDD VSS sg13g2_fill_2
XFILLER_76_242 VDD VSS sg13g2_decap_8
XFILLER_77_776 VDD VSS sg13g2_decap_8
X_4338__388 VDD VSS _4338_/RESET_B sg13g2_tiehi
XFILLER_36_106 VDD VSS sg13g2_decap_8
XFILLER_37_618 VDD VSS sg13g2_decap_8
XFILLER_91_201 VDD VSS sg13g2_fill_1
XFILLER_44_150 VDD VSS sg13g2_decap_8
XFILLER_45_684 VDD VSS sg13g2_fill_1
XFILLER_60_610 VDD VSS sg13g2_decap_8
X_4384__342 VDD VSS _4384_/RESET_B sg13g2_tiehi
X_3760_ _3764_/D _4765_/Q _3832_/A _3761_/B VDD VSS sg13g2_a21o_1
XFILLER_13_592 VDD VSS sg13g2_decap_8
X_2711_ _2711_/Y _2711_/A _2711_/B VDD VSS sg13g2_nand2_1
XFILLER_9_530 VDD VSS sg13g2_decap_8
X_3691_ _3691_/Y _3691_/A _4942_/D VDD VSS sg13g2_nand2_1
XFILLER_9_585 VDD VSS sg13g2_decap_8
X_2642_ VSS VDD _3868_/B _2488_/B _2642_/Y _2641_/Y sg13g2_a21oi_1
X_2573_ _2573_/A _2576_/C _2573_/Y VDD VSS sg13g2_nor2_1
X_4312_ _4312_/RESET_B VSS VDD _4312_/D _4312_/Q _4559_/CLK sg13g2_dfrbpq_1
X_4243_ _4243_/B1 VDD _4243_/Y VSS _4240_/Y _4241_/Y sg13g2_o21ai_1
XFILLER_67_220 VDD VSS sg13g2_decap_8
X_4436__490 VDD VSS _4436_/RESET_B sg13g2_tiehi
X_4174_ _4241_/B1 VDD _4174_/Y VSS _4205_/A1 _4174_/A2 sg13g2_o21ai_1
XFILLER_110_895 VDD VSS sg13g2_fill_1
XFILLER_83_724 VDD VSS sg13g2_decap_8
X_3125_ _4630_/Q _3125_/A1 _3138_/B _3125_/X VDD VSS sg13g2_mux2_1
XFILLER_55_448 VDD VSS sg13g2_decap_8
XFILLER_67_286 VDD VSS sg13g2_decap_8
XFILLER_83_757 VDD VSS sg13g2_decap_4
X_3056_ _3543_/A1 hold999/X _3056_/S _4482_/D VDD VSS sg13g2_mux2_1
XFILLER_36_662 VDD VSS sg13g2_decap_8
XFILLER_23_356 VDD VSS sg13g2_decap_8
XFILLER_24_868 VDD VSS sg13g2_decap_4
XFILLER_50_131 VDD VSS sg13g2_decap_8
XFILLER_51_654 VDD VSS sg13g2_decap_8
XFILLER_11_507 VDD VSS sg13g2_fill_1
XFILLER_50_197 VDD VSS sg13g2_decap_8
X_3958_ VSS VDD _2480_/B _3956_/A _3958_/Y _3957_/Y sg13g2_a21oi_1
X_4443__483 VDD VSS _4443_/RESET_B sg13g2_tiehi
X_3889_ _4805_/Q _3889_/C _4804_/Q _3889_/Y VDD VSS _3939_/C sg13g2_nand4_1
X_2909_ _2909_/A0 _3091_/A0 _2926_/S _2909_/X VDD VSS sg13g2_mux2_1
XFILLER_4_7 VDD VSS sg13g2_decap_8
XFILLER_104_155 VDD VSS sg13g2_decap_4
XFILLER_105_656 VDD VSS sg13g2_decap_4
XFILLER_116_21 VDD VSS sg13g2_decap_8
XFILLER_59_710 VDD VSS sg13g2_fill_1
XFILLER_76_14 VDD VSS sg13g2_decap_4
XFILLER_101_851 VDD VSS sg13g2_decap_8
XFILLER_104_199 VDD VSS sg13g2_decap_4
XFILLER_116_98 VDD VSS sg13g2_decap_8
XFILLER_58_220 VDD VSS sg13g2_decap_8
XFILLER_76_47 VDD VSS sg13g2_decap_8
XFILLER_74_713 VDD VSS sg13g2_decap_8
XFILLER_86_573 VDD VSS sg13g2_fill_2
XFILLER_100_383 VDD VSS sg13g2_fill_2
XFILLER_18_128 VDD VSS sg13g2_decap_4
XFILLER_73_212 VDD VSS sg13g2_decap_8
X_4450__476 VDD VSS _4450_/RESET_B sg13g2_tiehi
XFILLER_27_651 VDD VSS sg13g2_fill_1
XFILLER_92_35 VDD VSS sg13g2_decap_8
XFILLER_15_824 VDD VSS sg13g2_decap_8
XFILLER_15_835 VDD VSS sg13g2_fill_2
XFILLER_15_846 VDD VSS sg13g2_fill_2
XFILLER_26_161 VDD VSS sg13g2_decap_8
XFILLER_54_481 VDD VSS sg13g2_decap_8
XFILLER_42_643 VDD VSS sg13g2_fill_1
XFILLER_10_540 VDD VSS sg13g2_fill_1
XFILLER_6_566 VDD VSS sg13g2_decap_4
XFILLER_2_750 VDD VSS sg13g2_decap_8
XFILLER_97_805 VDD VSS sg13g2_fill_2
XFILLER_1_260 VDD VSS sg13g2_decap_8
XFILLER_37_7 VDD VSS sg13g2_decap_8
XFILLER_96_315 VDD VSS sg13g2_decap_8
XFILLER_49_220 VDD VSS sg13g2_decap_4
XFILLER_49_275 VDD VSS sg13g2_decap_8
XFILLER_65_724 VDD VSS sg13g2_decap_8
XFILLER_92_510 VDD VSS sg13g2_fill_1
XFILLER_49_286 VDD VSS sg13g2_fill_2
XFILLER_77_595 VDD VSS sg13g2_decap_8
XFILLER_18_640 VDD VSS sg13g2_decap_4
XFILLER_66_91 VDD VSS sg13g2_decap_8
XFILLER_80_716 VDD VSS sg13g2_decap_8
XFILLER_18_684 VDD VSS sg13g2_decap_8
X_4930_ fanout328/X VSS VDD _4930_/D _4930_/Q _4955_/CLK sg13g2_dfrbpq_1
XFILLER_92_587 VDD VSS sg13g2_decap_8
XFILLER_21_805 VDD VSS sg13g2_decap_8
XFILLER_32_120 VDD VSS sg13g2_decap_8
X_4861_ fanout325/X VSS VDD _4861_/D _4861_/Q _4870_/CLK sg13g2_dfrbpq_1
XFILLER_82_90 VDD VSS sg13g2_fill_2
X_3812_ _3827_/A VDD _3812_/Y VSS _3814_/A _3811_/Y sg13g2_o21ai_1
XFILLER_32_175 VDD VSS sg13g2_decap_8
XFILLER_60_495 VDD VSS sg13g2_decap_8
X_4792_ fanout247/X VSS VDD _4792_/D _4792_/Q _4904_/CLK sg13g2_dfrbpq_1
X_3743_ _3743_/Y _3743_/A _3745_/C VDD VSS sg13g2_xnor2_1
X_3674_ _3674_/B _4742_/Q _3674_/X VDD VSS sg13g2_xor2_1
XFILLER_9_371 VDD VSS sg13g2_decap_8
XFILLER_63_0 VDD VSS sg13g2_decap_8
X_2625_ _4903_/D _3807_/C _2625_/Y VDD VSS sg13g2_nor2b_1
X_2556_ _2561_/C _2556_/A _2556_/B _2556_/C VDD VSS sg13g2_and3_1
XFILLER_101_103 VDD VSS sg13g2_decap_8
X_2487_ _4927_/Q _3868_/A _2641_/B VDD VSS sg13g2_nor2b_1
XFILLER_99_175 VDD VSS sg13g2_decap_8
XFILLER_88_849 VDD VSS sg13g2_decap_8
X_4226_ _4052_/A _4282_/Q _4307_/Q _4332_/Q _4357_/Q _4226_/S1 _4226_/X VDD VSS sg13g2_mux4_1
XFILLER_101_158 VDD VSS sg13g2_decap_8
XFILLER_56_713 VDD VSS sg13g2_decap_4
X_4157_ _4157_/Y _4157_/B _4236_/B1 VDD VSS sg13g2_nand2b_1
XFILLER_28_426 VDD VSS sg13g2_fill_1
XFILLER_28_448 VDD VSS sg13g2_decap_8
XFILLER_46_28 VDD VSS sg13g2_decap_4
XFILLER_46_39 VDD VSS sg13g2_fill_2
XFILLER_55_234 VDD VSS sg13g2_decap_8
XFILLER_68_595 VDD VSS sg13g2_decap_8
X_3108_ _3108_/A0 _3138_/A _3108_/S _4532_/D VDD VSS sg13g2_mux2_1
XFILLER_95_381 VDD VSS sg13g2_decap_8
XFILLER_55_267 VDD VSS sg13g2_decap_8
XFILLER_56_768 VDD VSS sg13g2_decap_8
X_4088_ _4088_/Y _4088_/B _4147_/B1 VDD VSS sg13g2_nand2b_1
XFILLER_15_109 VDD VSS sg13g2_decap_8
X_3039_ _3550_/A1 _3064_/A1 _3056_/S _4465_/D VDD VSS sg13g2_mux2_1
XFILLER_102_56 VDD VSS sg13g2_decap_8
X_4328__398 VDD VSS _4328_/RESET_B sg13g2_tiehi
XFILLER_11_31 VDD VSS sg13g2_decap_4
XFILLER_105_420 VDD VSS sg13g2_decap_8
XFILLER_11_97 VDD VSS sg13g2_decap_8
XFILLER_78_304 VDD VSS sg13g2_fill_2
XFILLER_87_46 VDD VSS sg13g2_decap_8
XFILLER_59_540 VDD VSS sg13g2_fill_2
X_4374__352 VDD VSS _4374_/RESET_B sg13g2_tiehi
XFILLER_93_318 VDD VSS sg13g2_fill_1
XFILLER_101_692 VDD VSS sg13g2_decap_8
XFILLER_19_426 VDD VSS sg13g2_fill_2
XFILLER_46_201 VDD VSS sg13g2_fill_2
XFILLER_46_234 VDD VSS sg13g2_decap_4
XFILLER_46_245 VDD VSS sg13g2_fill_1
XFILLER_46_256 VDD VSS sg13g2_fill_1
XFILLER_47_768 VDD VSS sg13g2_decap_8
XFILLER_47_779 VDD VSS sg13g2_fill_1
XFILLER_15_654 VDD VSS sg13g2_decap_8
XFILLER_61_248 VDD VSS sg13g2_fill_2
XFILLER_61_259 VDD VSS sg13g2_decap_8
XFILLER_42_451 VDD VSS sg13g2_decap_4
XFILLER_14_175 VDD VSS sg13g2_decap_8
XFILLER_42_484 VDD VSS sg13g2_decap_8
X_4381__345 VDD VSS _4381_/RESET_B sg13g2_tiehi
XFILLER_7_886 VDD VSS sg13g2_decap_8
Xhold809 _3050_/X VDD VSS _4476_/D sg13g2_dlygate4sd3_1
X_2410_ _2809_/B _2410_/A _2807_/B VDD VSS sg13g2_nand2_1
X_3390_ _3390_/A _4793_/Q _3390_/C _3390_/Y VDD VSS sg13g2_nor3_1
XFILLER_97_602 VDD VSS sg13g2_decap_8
XFILLER_35_4 VDD VSS sg13g2_decap_8
X_2341_ VDD _3979_/B _2341_/A VSS sg13g2_inv_1
XFILLER_111_423 VDD VSS sg13g2_decap_8
XFILLER_69_348 VDD VSS sg13g2_decap_8
X_2272_ VDD _2272_/Y _4656_/Q VSS sg13g2_inv_1
XFILLER_38_713 VDD VSS sg13g2_decap_8
XFILLER_77_90 VDD VSS sg13g2_decap_4
Xhold1509 _4574_/Q VDD VSS _3176_/A sg13g2_dlygate4sd3_1
X_4011_ _4186_/S _4411_/Q _4011_/Y VDD VSS sg13g2_nor2_1
XFILLER_37_201 VDD VSS sg13g2_fill_1
XFILLER_65_521 VDD VSS sg13g2_decap_8
XFILLER_25_407 VDD VSS sg13g2_decap_8
XFILLER_38_779 VDD VSS sg13g2_decap_8
X_4433__493 VDD VSS _4433_/RESET_B sg13g2_tiehi
XFILLER_52_215 VDD VSS sg13g2_fill_1
XFILLER_80_513 VDD VSS sg13g2_decap_8
XFILLER_92_362 VDD VSS sg13g2_decap_8
X_4913_ fanout261/X VSS VDD _4913_/D _4913_/Q clkload7/A sg13g2_dfrbpq_1
XFILLER_21_635 VDD VSS sg13g2_decap_8
XFILLER_33_495 VDD VSS sg13g2_fill_2
XFILLER_61_793 VDD VSS sg13g2_decap_8
X_4844_ fanout317/X VSS VDD _4844_/D _4844_/Q _4931_/CLK sg13g2_dfrbpq_1
X_4775_ fanout247/X VSS VDD _4775_/D _4775_/Q _4904_/CLK sg13g2_dfrbpq_1
X_3726_ _3726_/Y _3726_/A _3726_/B VDD VSS sg13g2_nand2_1
XFILLER_106_217 VDD VSS sg13g2_decap_8
X_4440__486 VDD VSS _4440_/RESET_B sg13g2_tiehi
X_3657_ _3717_/A VDD _3657_/Y VSS _4746_/Q _3717_/B sg13g2_o21ai_1
XFILLER_115_740 VDD VSS sg13g2_decap_8
X_3588_ _3588_/Y _3588_/A _3588_/B VDD VSS sg13g2_xnor2_1
X_2608_ _2609_/A _3251_/B _3253_/B VDD VSS sg13g2_and2_1
XFILLER_114_261 VDD VSS sg13g2_decap_8
X_2539_ _2541_/B _2539_/B _4873_/D VDD VSS sg13g2_and2_1
XFILLER_102_423 VDD VSS sg13g2_decap_8
XFILLER_76_808 VDD VSS sg13g2_decap_4
XFILLER_87_145 VDD VSS sg13g2_decap_8
XFILLER_75_307 VDD VSS sg13g2_decap_8
XFILLER_56_510 VDD VSS sg13g2_fill_2
XFILLER_68_381 VDD VSS sg13g2_decap_8
X_4209_ _4236_/B1 VDD _4209_/Y VSS _4236_/A1 _4208_/X sg13g2_o21ai_1
XFILLER_96_690 VDD VSS sg13g2_decap_8
XFILLER_87_189 VDD VSS sg13g2_fill_1
XFILLER_29_757 VDD VSS sg13g2_fill_2
XFILLER_24_462 VDD VSS sg13g2_decap_8
XFILLER_12_668 VDD VSS sg13g2_decap_4
XFILLER_20_690 VDD VSS sg13g2_decap_8
XFILLER_22_74 VDD VSS sg13g2_decap_8
XFILLER_7_149 VDD VSS sg13g2_decap_8
XFILLER_4_823 VDD VSS sg13g2_decap_8
XFILLER_106_762 VDD VSS sg13g2_decap_4
XFILLER_106_773 VDD VSS sg13g2_fill_2
XFILLER_98_78 VDD VSS sg13g2_fill_2
XFILLER_79_646 VDD VSS sg13g2_decap_8
XFILLER_75_841 VDD VSS sg13g2_fill_2
Xfanout180 _4232_/B1 _2347_/A VDD VSS sg13g2_buf_1
Xfanout191 _4242_/S _4144_/S VDD VSS sg13g2_buf_1
XFILLER_93_115 VDD VSS sg13g2_decap_8
XFILLER_47_71 VDD VSS sg13g2_decap_8
XFILLER_47_82 VDD VSS sg13g2_fill_2
XFILLER_75_874 VDD VSS sg13g2_fill_1
XFILLER_90_800 VDD VSS sg13g2_fill_1
XFILLER_35_727 VDD VSS sg13g2_decap_8
XFILLER_34_248 VDD VSS sg13g2_decap_8
XFILLER_50_708 VDD VSS sg13g2_decap_8
XFILLER_90_866 VDD VSS sg13g2_decap_8
XFILLER_31_922 VDD VSS sg13g2_decap_4
X_2890_ _2890_/A0 _3098_/A0 _2901_/S _4323_/D VDD VSS sg13g2_mux2_1
XFILLER_30_454 VDD VSS sg13g2_decap_4
X_4560_ fanout317/X VSS VDD _4560_/D _4560_/Q _4931_/CLK sg13g2_dfrbpq_1
XFILLER_7_661 VDD VSS sg13g2_decap_8
XFILLER_8_98 VDD VSS sg13g2_decap_8
XFILLER_116_526 VDD VSS sg13g2_decap_8
Xhold606 _4535_/Q VDD VSS hold606/X sg13g2_dlygate4sd3_1
Xhold617 _2424_/Y VDD VSS _4922_/D sg13g2_dlygate4sd3_1
X_4491_ fanout321/X VSS VDD _4491_/D _4491_/Q _4979_/CLK sg13g2_dfrbpq_1
X_3511_ _3511_/Y _3511_/A _3511_/B VDD VSS sg13g2_nand2_1
Xhold628 _4883_/Q VDD VSS _2561_/A sg13g2_dlygate4sd3_1
Xhold639 _4067_/Y VDD VSS _4960_/D sg13g2_dlygate4sd3_1
X_3442_ _3441_/Y VDD _3442_/Y VSS _2276_/Y _3443_/C sg13g2_o21ai_1
X_3373_ _4902_/Q _4903_/Q _3373_/Y VDD VSS sg13g2_nor2_1
XFILLER_69_123 VDD VSS sg13g2_decap_8
X_2324_ VDD _2324_/Y _2324_/A VSS sg13g2_inv_1
XFILLER_26_0 VDD VSS sg13g2_decap_8
Xhold1306 _2798_/Y VDD VSS _2799_/C sg13g2_dlygate4sd3_1
XFILLER_97_476 VDD VSS sg13g2_decap_8
XFILLER_112_798 VDD VSS sg13g2_decap_8
Xhold1317 _3248_/Y VDD VSS _4604_/D sg13g2_dlygate4sd3_1
Xhold1328 _3534_/X VDD VSS _4696_/D sg13g2_dlygate4sd3_1
Xhold1339 _4916_/Q VDD VSS _2392_/C sg13g2_dlygate4sd3_1
X_2255_ VDD _2686_/B _4725_/Q VSS sg13g2_inv_1
XFILLER_85_649 VDD VSS sg13g2_decap_8
XFILLER_38_554 VDD VSS sg13g2_fill_2
XFILLER_84_159 VDD VSS sg13g2_decap_8
XFILLER_25_204 VDD VSS sg13g2_fill_1
XFILLER_81_822 VDD VSS sg13g2_decap_4
XFILLER_81_877 VDD VSS sg13g2_fill_1
XFILLER_22_922 VDD VSS sg13g2_decap_4
XFILLER_80_398 VDD VSS sg13g2_decap_8
X_4827_ fanout314/X VSS VDD _4827_/D _4827_/Q _4965_/CLK sg13g2_dfrbpq_1
XFILLER_21_476 VDD VSS sg13g2_decap_8
XFILLER_21_487 VDD VSS sg13g2_fill_1
X_4364__362 VDD VSS _4364_/RESET_B sg13g2_tiehi
XFILLER_5_609 VDD VSS sg13g2_fill_1
X_4758_ fanout257/X VSS VDD _4758_/D _4758_/Q _4907_/CLK sg13g2_dfrbpq_1
X_4689_ fanout325/X VSS VDD _4689_/D _4689_/Q _4868_/CLK sg13g2_dfrbpq_1
X_3709_ VDD VSS _3668_/Y _3636_/C _3708_/Y _3698_/C _3709_/Y _3705_/Y sg13g2_a221oi_1
XFILLER_104_7 VDD VSS sg13g2_decap_8
XFILLER_108_77 VDD VSS sg13g2_decap_8
XFILLER_108_88 VDD VSS sg13g2_fill_1
XFILLER_1_859 VDD VSS sg13g2_decap_8
XFILLER_0_347 VDD VSS sg13g2_decap_8
XFILLER_48_307 VDD VSS sg13g2_decap_8
XFILLER_49_808 VDD VSS sg13g2_decap_8
X_4371__355 VDD VSS _4371_/RESET_B sg13g2_tiehi
XFILLER_16_204 VDD VSS sg13g2_decap_8
XFILLER_72_833 VDD VSS sg13g2_decap_8
XFILLER_90_118 VDD VSS sg13g2_decap_8
XFILLER_72_866 VDD VSS sg13g2_decap_8
XFILLER_83_170 VDD VSS sg13g2_decap_8
XFILLER_25_771 VDD VSS sg13g2_fill_2
XFILLER_71_365 VDD VSS sg13g2_decap_8
XFILLER_12_421 VDD VSS sg13g2_fill_2
XFILLER_25_793 VDD VSS sg13g2_decap_8
XFILLER_33_62 VDD VSS sg13g2_decap_8
XFILLER_8_447 VDD VSS sg13g2_fill_2
XFILLER_3_174 VDD VSS sg13g2_decap_8
XFILLER_4_697 VDD VSS sg13g2_decap_8
XFILLER_95_925 VDD VSS sg13g2_fill_1
XFILLER_95_914 VDD VSS sg13g2_decap_8
XFILLER_67_638 VDD VSS sg13g2_decap_8
XFILLER_94_435 VDD VSS sg13g2_fill_2
XFILLER_47_373 VDD VSS sg13g2_decap_8
XFILLER_48_885 VDD VSS sg13g2_decap_8
XFILLER_81_118 VDD VSS sg13g2_decap_8
XFILLER_81_129 VDD VSS sg13g2_fill_2
XFILLER_62_310 VDD VSS sg13g2_decap_8
XFILLER_74_170 VDD VSS sg13g2_decap_8
XFILLER_63_877 VDD VSS sg13g2_decap_8
X_4430__496 VDD VSS _4430_/RESET_B sg13g2_tiehi
X_3991_ _3999_/A _3991_/B _3991_/Y VDD VSS sg13g2_nor2_1
X_2942_ hold829/X _3021_/A1 _2953_/S _2942_/X VDD VSS sg13g2_mux2_1
XFILLER_15_292 VDD VSS sg13g2_decap_8
X_2873_ _2873_/A0 _3032_/A1 _2873_/S _4308_/D VDD VSS sg13g2_mux2_1
XFILLER_30_295 VDD VSS sg13g2_decap_8
Xclkbuf_4_4_0_clk clkbuf_0_clk/X clkbuf_4_4_0_clk/X VDD VSS sg13g2_buf_8
X_4612_ fanout281/X VSS VDD _4612_/D _4612_/Q _4619_/CLK sg13g2_dfrbpq_1
X_4543_ fanout288/X VSS VDD _4543_/D _4543_/Q _4927_/CLK sg13g2_dfrbpq_1
X_4474_ fanout302/X VSS VDD _4474_/D _4474_/Q _4974_/CLK sg13g2_dfrbpq_1
X_3425_ _3425_/B _3425_/C _3425_/A _3425_/Y VDD VSS sg13g2_nand3_1
XFILLER_112_562 VDD VSS sg13g2_fill_2
X_3356_ _3353_/A _3357_/A _3357_/C _3359_/B VDD VSS sg13g2_a21o_1
XFILLER_97_251 VDD VSS sg13g2_decap_8
XFILLER_86_925 VDD VSS sg13g2_fill_1
XFILLER_86_914 VDD VSS sg13g2_decap_8
XFILLER_112_573 VDD VSS sg13g2_decap_8
Xhold1103 _3047_/X VDD VSS _4473_/D sg13g2_dlygate4sd3_1
Xhold1114 _3090_/X VDD VSS _4514_/D sg13g2_dlygate4sd3_1
X_3287_ VSS VDD _2308_/Y _3286_/Y _4620_/D _3289_/A sg13g2_a21oi_1
X_2307_ VDD _3268_/A _2613_/A VSS sg13g2_inv_1
Xhold1125 _3007_/X VDD VSS _4434_/D sg13g2_dlygate4sd3_1
Xhold1136 _3533_/X VDD VSS _4695_/D sg13g2_dlygate4sd3_1
Xhold1147 _2841_/X VDD VSS _4278_/D sg13g2_dlygate4sd3_1
Xhold1158 _4391_/Q VDD VSS _2962_/A0 sg13g2_dlygate4sd3_1
X_2238_ VDD _2238_/Y _4931_/Q VSS sg13g2_inv_1
XFILLER_85_457 VDD VSS sg13g2_decap_8
XFILLER_26_502 VDD VSS sg13g2_decap_8
XFILLER_73_619 VDD VSS sg13g2_fill_2
Xhold1169 _2859_/X VDD VSS _4294_/D sg13g2_dlygate4sd3_1
XFILLER_54_28 VDD VSS sg13g2_decap_8
XFILLER_41_516 VDD VSS sg13g2_fill_1
XFILLER_54_866 VDD VSS sg13g2_decap_4
XFILLER_80_140 VDD VSS sg13g2_decap_8
XFILLER_53_376 VDD VSS sg13g2_decap_8
XFILLER_110_56 VDD VSS sg13g2_decap_8
XFILLER_22_752 VDD VSS sg13g2_decap_8
XFILLER_10_925 VDD VSS sg13g2_fill_1
XFILLER_21_240 VDD VSS sg13g2_decap_8
XFILLER_108_857 VDD VSS sg13g2_decap_8
XFILLER_108_868 VDD VSS sg13g2_decap_8
XFILLER_5_439 VDD VSS sg13g2_fill_1
XFILLER_79_14 VDD VSS sg13g2_decap_8
XFILLER_79_69 VDD VSS sg13g2_decap_8
Xhold970 _2965_/X VDD VSS _4394_/D sg13g2_dlygate4sd3_1
Xhold981 _4436_/Q VDD VSS hold981/X sg13g2_dlygate4sd3_1
XFILLER_0_133 VDD VSS sg13g2_decap_8
XFILLER_1_656 VDD VSS sg13g2_fill_1
XFILLER_1_678 VDD VSS sg13g2_decap_4
XFILLER_49_605 VDD VSS sg13g2_decap_4
XFILLER_77_914 VDD VSS sg13g2_decap_8
XFILLER_77_925 VDD VSS sg13g2_fill_1
Xhold992 _4392_/Q VDD VSS hold992/X sg13g2_dlygate4sd3_1
XFILLER_89_763 VDD VSS sg13g2_fill_2
XFILLER_48_115 VDD VSS sg13g2_decap_8
XFILLER_88_284 VDD VSS sg13g2_decap_8
XFILLER_95_68 VDD VSS sg13g2_decap_8
XFILLER_88_295 VDD VSS sg13g2_fill_1
XFILLER_28_51 VDD VSS sg13g2_decap_8
XFILLER_29_373 VDD VSS sg13g2_decap_4
Xhold1670 _4766_/Q VDD VSS _3800_/C sg13g2_dlygate4sd3_1
XFILLER_44_321 VDD VSS sg13g2_fill_1
Xhold1681 _4599_/Q VDD VSS _2603_/A sg13g2_dlygate4sd3_1
XFILLER_45_866 VDD VSS sg13g2_decap_8
XFILLER_71_151 VDD VSS sg13g2_decap_8
XFILLER_44_398 VDD VSS sg13g2_decap_8
XFILLER_12_240 VDD VSS sg13g2_decap_4
XFILLER_13_796 VDD VSS sg13g2_decap_8
XFILLER_12_284 VDD VSS sg13g2_fill_1
XFILLER_9_778 VDD VSS sg13g2_fill_1
XFILLER_8_244 VDD VSS sg13g2_fill_1
XFILLER_67_7 VDD VSS sg13g2_decap_8
XFILLER_5_22 VDD VSS sg13g2_decap_8
XFILLER_4_450 VDD VSS sg13g2_decap_4
XFILLER_99_516 VDD VSS sg13g2_decap_8
XFILLER_114_849 VDD VSS sg13g2_decap_8
XFILLER_79_251 VDD VSS sg13g2_decap_8
X_4190_ VSS VDD _4190_/A1 _4186_/X _4190_/Y _4189_/Y sg13g2_a21oi_1
X_3210_ _2593_/B VDD _3210_/Y VSS _3208_/A _3208_/B sg13g2_o21ai_1
XFILLER_95_700 VDD VSS sg13g2_decap_8
X_3141_ _3140_/Y VDD _3141_/Y VSS _4631_/Q _3140_/B sg13g2_o21ai_1
X_4354__372 VDD VSS _4354_/RESET_B sg13g2_tiehi
XFILLER_95_777 VDD VSS sg13g2_decap_8
X_3072_ _4130_/B _3072_/A1 _3083_/S _4496_/D VDD VSS sg13g2_mux2_1
XFILLER_36_844 VDD VSS sg13g2_decap_8
XFILLER_48_682 VDD VSS sg13g2_decap_8
XFILLER_48_693 VDD VSS sg13g2_fill_1
XFILLER_82_438 VDD VSS sg13g2_fill_2
XFILLER_63_663 VDD VSS sg13g2_decap_8
XFILLER_63_674 VDD VSS sg13g2_fill_2
XFILLER_16_590 VDD VSS sg13g2_fill_2
XFILLER_50_335 VDD VSS sg13g2_decap_8
XFILLER_51_858 VDD VSS sg13g2_decap_8
X_3974_ VSS VDD _2630_/Y _3971_/Y _4829_/D _3973_/Y sg13g2_a21oi_1
XFILLER_93_0 VDD VSS sg13g2_decap_8
XFILLER_31_571 VDD VSS sg13g2_decap_4
X_2925_ _2925_/A0 _3107_/A0 _2928_/S _4357_/D VDD VSS sg13g2_mux2_1
X_2856_ hold955/X _3091_/A0 _2874_/S _2856_/X VDD VSS sg13g2_mux2_1
X_4361__365 VDD VSS _4361_/RESET_B sg13g2_tiehi
X_2787_ _2787_/B _2787_/C _2787_/A _2789_/A VDD VSS sg13g2_nand3_1
XFILLER_105_805 VDD VSS sg13g2_fill_2
X_4526_ fanout298/X VSS VDD _4526_/D _4526_/Q _4958_/CLK sg13g2_dfrbpq_1
XFILLER_104_315 VDD VSS sg13g2_decap_8
XFILLER_105_838 VDD VSS sg13g2_decap_8
XFILLER_116_186 VDD VSS sg13g2_decap_8
X_4457_ _4457_/RESET_B VSS VDD _4457_/D _4457_/Q clkload9/A sg13g2_dfrbpq_1
X_3408_ _3421_/A _3425_/A _3408_/A _3408_/Y VDD VSS sg13g2_nand3_1
XFILLER_86_700 VDD VSS sg13g2_fill_2
XFILLER_100_510 VDD VSS sg13g2_decap_8
X_4388_ _4388_/RESET_B VSS VDD _4388_/D _4388_/Q clkload9/A sg13g2_dfrbpq_1
XFILLER_105_56 VDD VSS sg13g2_decap_8
X_3339_ _3339_/Y _3406_/A _3339_/B VDD VSS sg13g2_nand2_1
XFILLER_65_49 VDD VSS sg13g2_decap_8
XFILLER_85_265 VDD VSS sg13g2_fill_1
XFILLER_38_170 VDD VSS sg13g2_fill_1
XFILLER_54_641 VDD VSS sg13g2_fill_1
XFILLER_14_516 VDD VSS sg13g2_decap_8
XFILLER_41_313 VDD VSS sg13g2_decap_8
XFILLER_53_151 VDD VSS sg13g2_decap_8
XFILLER_81_59 VDD VSS sg13g2_decap_8
XFILLER_10_711 VDD VSS sg13g2_fill_2
XFILLER_14_31 VDD VSS sg13g2_fill_2
XFILLER_10_744 VDD VSS sg13g2_decap_8
XFILLER_108_632 VDD VSS sg13g2_decap_8
XFILLER_108_643 VDD VSS sg13g2_fill_1
XFILLER_5_214 VDD VSS sg13g2_fill_1
XFILLER_107_153 VDD VSS sg13g2_decap_8
XFILLER_108_687 VDD VSS sg13g2_decap_8
XFILLER_107_197 VDD VSS sg13g2_decap_8
XFILLER_110_318 VDD VSS sg13g2_decap_8
XFILLER_1_486 VDD VSS sg13g2_decap_4
XFILLER_39_50 VDD VSS sg13g2_decap_8
XFILLER_49_424 VDD VSS sg13g2_decap_8
XFILLER_77_722 VDD VSS sg13g2_fill_2
XFILLER_77_755 VDD VSS sg13g2_decap_8
XFILLER_18_811 VDD VSS sg13g2_decap_8
XFILLER_76_298 VDD VSS sg13g2_decap_8
Xclkbuf_leaf_56_clk clkbuf_4_3_0_clk/X clkload9/A VDD VSS sg13g2_buf_8
XFILLER_92_736 VDD VSS sg13g2_decap_4
XFILLER_17_354 VDD VSS sg13g2_decap_8
XFILLER_18_855 VDD VSS sg13g2_decap_8
XFILLER_45_663 VDD VSS sg13g2_decap_8
XFILLER_33_825 VDD VSS sg13g2_decap_4
XFILLER_55_93 VDD VSS sg13g2_decap_4
XFILLER_60_600 VDD VSS sg13g2_decap_4
XFILLER_72_460 VDD VSS sg13g2_decap_8
XFILLER_72_471 VDD VSS sg13g2_fill_1
XFILLER_72_482 VDD VSS sg13g2_decap_4
XFILLER_44_195 VDD VSS sg13g2_fill_2
XFILLER_13_571 VDD VSS sg13g2_decap_8
XFILLER_20_519 VDD VSS sg13g2_decap_8
XFILLER_41_880 VDD VSS sg13g2_decap_8
XFILLER_40_390 VDD VSS sg13g2_decap_8
XFILLER_41_891 VDD VSS sg13g2_fill_2
X_2710_ _4863_/Q _2710_/C _3555_/A _2711_/B VDD VSS sg13g2_nand3_1
X_3690_ _3690_/Y _3690_/A _3690_/B VDD VSS sg13g2_xnor2_1
X_2641_ _2641_/Y _2641_/B _3866_/A VDD VSS sg13g2_nand2b_1
XFILLER_114_602 VDD VSS sg13g2_decap_4
X_2572_ _2572_/A _2572_/B _2572_/C _2576_/C VDD VSS sg13g2_nor3_1
XFILLER_5_781 VDD VSS sg13g2_decap_8
X_4311_ _4311_/RESET_B VSS VDD _4311_/D _4311_/Q _4527_/CLK sg13g2_dfrbpq_1
XFILLER_99_335 VDD VSS sg13g2_fill_1
XFILLER_99_324 VDD VSS sg13g2_decap_8
X_4242_ _4384_/Q _4409_/Q _4242_/S _4242_/X VDD VSS sg13g2_mux2_1
XFILLER_87_519 VDD VSS sg13g2_decap_8
XFILLER_87_508 VDD VSS sg13g2_fill_2
XFILLER_68_744 VDD VSS sg13g2_decap_8
X_4173_ _4240_/A _4173_/B _4173_/Y VDD VSS sg13g2_nor2_1
X_3124_ _4629_/Q _3124_/A1 _3136_/B _3124_/X VDD VSS sg13g2_mux2_1
XFILLER_55_427 VDD VSS sg13g2_decap_8
X_3055_ hold790/X _3082_/A1 _3057_/S _4481_/D VDD VSS sg13g2_mux2_1
XFILLER_36_641 VDD VSS sg13g2_decap_8
Xclkbuf_leaf_47_clk clkbuf_4_10_0_clk/X _4884_/CLK VDD VSS sg13g2_buf_8
XFILLER_23_302 VDD VSS sg13g2_decap_8
XFILLER_24_814 VDD VSS sg13g2_decap_8
XFILLER_63_482 VDD VSS sg13g2_decap_8
XFILLER_23_335 VDD VSS sg13g2_decap_8
XFILLER_35_184 VDD VSS sg13g2_decap_4
XFILLER_35_195 VDD VSS sg13g2_decap_4
XFILLER_50_110 VDD VSS sg13g2_decap_8
XFILLER_51_633 VDD VSS sg13g2_decap_8
X_3957_ VSS VDD _3948_/C _3951_/Y _3957_/Y _2480_/B sg13g2_a21oi_1
XFILLER_50_176 VDD VSS sg13g2_decap_8
X_2908_ hold939/X _3090_/A0 _2928_/S _2908_/X VDD VSS sg13g2_mux2_1
XFILLER_109_429 VDD VSS sg13g2_decap_8
X_3888_ VSS VDD _3901_/C _3911_/B _3888_/Y _3930_/A sg13g2_a21oi_1
X_2839_ hold843/X _3101_/A0 _2842_/S _2839_/X VDD VSS sg13g2_mux2_1
XFILLER_105_635 VDD VSS sg13g2_decap_8
X_4509_ fanout322/X VSS VDD _4509_/D _4509_/Q _4979_/CLK sg13g2_dfrbpq_1
XFILLER_104_123 VDD VSS sg13g2_decap_4
XFILLER_2_239 VDD VSS sg13g2_fill_1
XFILLER_78_519 VDD VSS sg13g2_decap_8
XFILLER_101_830 VDD VSS sg13g2_decap_8
XFILLER_116_77 VDD VSS sg13g2_decap_8
XFILLER_27_630 VDD VSS sg13g2_fill_2
XFILLER_46_449 VDD VSS sg13g2_decap_8
XFILLER_15_803 VDD VSS sg13g2_decap_8
XFILLER_26_140 VDD VSS sg13g2_decap_8
Xclkbuf_leaf_38_clk clkbuf_4_12_0_clk/X _4961_/CLK VDD VSS sg13g2_buf_8
XFILLER_14_313 VDD VSS sg13g2_decap_4
XFILLER_42_622 VDD VSS sg13g2_fill_2
XFILLER_54_460 VDD VSS sg13g2_decap_8
XFILLER_70_920 VDD VSS sg13g2_decap_4
XFILLER_14_368 VDD VSS sg13g2_decap_8
XFILLER_42_688 VDD VSS sg13g2_decap_8
XFILLER_10_585 VDD VSS sg13g2_decap_8
XFILLER_41_62 VDD VSS sg13g2_decap_8
XFILLER_6_545 VDD VSS sg13g2_decap_8
X_4344__382 VDD VSS _4344_/RESET_B sg13g2_tiehi
XFILLER_108_451 VDD VSS sg13g2_decap_8
XFILLER_108_462 VDD VSS sg13g2_fill_1
XFILLER_108_484 VDD VSS sg13g2_decap_8
XFILLER_110_126 VDD VSS sg13g2_decap_8
XFILLER_1_283 VDD VSS sg13g2_decap_4
XFILLER_96_349 VDD VSS sg13g2_decap_8
XFILLER_110_159 VDD VSS sg13g2_fill_2
XFILLER_2_56 VDD VSS sg13g2_fill_2
XFILLER_65_703 VDD VSS sg13g2_decap_8
XFILLER_77_563 VDD VSS sg13g2_decap_8
XFILLER_37_427 VDD VSS sg13g2_fill_1
XFILLER_37_438 VDD VSS sg13g2_decap_8
XFILLER_66_70 VDD VSS sg13g2_decap_8
XFILLER_64_235 VDD VSS sg13g2_decap_8
Xclkbuf_leaf_29_clk clkbuf_4_15_0_clk/X _4955_/CLK VDD VSS sg13g2_buf_8
X_4351__375 VDD VSS _4351_/RESET_B sg13g2_tiehi
XFILLER_92_566 VDD VSS sg13g2_decap_8
XFILLER_45_482 VDD VSS sg13g2_decap_8
X_4860_ fanout325/X VSS VDD _4860_/D _4860_/Q _4868_/CLK sg13g2_dfrbpq_1
XFILLER_32_154 VDD VSS sg13g2_decap_8
X_3811_ _3811_/A _4759_/Q _3811_/Y VDD VSS sg13g2_nor2b_1
X_4791_ fanout247/X VSS VDD _4791_/D _4791_/Q _4904_/CLK sg13g2_dfrbpq_1
XFILLER_20_349 VDD VSS sg13g2_decap_8
X_3742_ _3742_/Y _3743_/A _3758_/B VDD VSS sg13g2_nand2_1
XFILLER_9_350 VDD VSS sg13g2_decap_8
X_3673_ _4742_/Q _3674_/B _3690_/B VDD VSS sg13g2_nor2_1
XFILLER_9_394 VDD VSS sg13g2_decap_8
X_2624_ _3807_/C _3728_/A _2756_/B VDD VSS sg13g2_nand2_1
XFILLER_115_922 VDD VSS sg13g2_decap_4
XFILLER_56_0 VDD VSS sg13g2_decap_8
X_2555_ _2556_/C _2556_/A _2555_/X VDD VSS sg13g2_xor2_1
XFILLER_99_154 VDD VSS sg13g2_decap_8
XFILLER_114_487 VDD VSS sg13g2_decap_4
X_2486_ _2486_/A _2486_/B _2488_/B VDD VSS sg13g2_nor2_1
XFILLER_87_316 VDD VSS sg13g2_decap_4
X_4225_ VSS VDD _4225_/A1 _4221_/X _4225_/Y _4224_/Y sg13g2_a21oi_1
XFILLER_87_338 VDD VSS sg13g2_fill_1
XFILLER_28_405 VDD VSS sg13g2_decap_8
X_4156_ _4236_/B1 VDD _4156_/Y VSS _4236_/A1 _4155_/X sg13g2_o21ai_1
XFILLER_95_360 VDD VSS sg13g2_decap_8
XFILLER_55_213 VDD VSS sg13g2_decap_8
XFILLER_56_747 VDD VSS sg13g2_decap_8
XFILLER_83_511 VDD VSS sg13g2_fill_2
X_3107_ _3107_/A0 _3136_/A _3109_/S _4531_/D VDD VSS sg13g2_mux2_1
XFILLER_55_246 VDD VSS sg13g2_decap_8
XFILLER_71_717 VDD VSS sg13g2_decap_8
X_4087_ _4147_/B1 VDD _4087_/Y VSS _4245_/A1 _4081_/X sg13g2_o21ai_1
XFILLER_102_35 VDD VSS sg13g2_decap_8
XFILLER_24_600 VDD VSS sg13g2_decap_8
XFILLER_24_611 VDD VSS sg13g2_fill_2
XFILLER_36_460 VDD VSS sg13g2_decap_8
XFILLER_36_471 VDD VSS sg13g2_fill_1
XFILLER_52_920 VDD VSS sg13g2_decap_4
X_3038_ hold849/X _4489_/Q _3051_/S _3038_/X VDD VSS sg13g2_mux2_1
XFILLER_23_110 VDD VSS sg13g2_decap_8
XFILLER_62_28 VDD VSS sg13g2_decap_8
XFILLER_70_238 VDD VSS sg13g2_decap_8
XFILLER_23_143 VDD VSS sg13g2_decap_8
XFILLER_109_237 VDD VSS sg13g2_decap_8
XFILLER_109_259 VDD VSS sg13g2_decap_8
XFILLER_11_21 VDD VSS sg13g2_fill_1
XFILLER_11_76 VDD VSS sg13g2_decap_8
XFILLER_79_806 VDD VSS sg13g2_fill_1
XFILLER_87_14 VDD VSS sg13g2_decap_8
XFILLER_105_476 VDD VSS sg13g2_decap_8
XFILLER_19_405 VDD VSS sg13g2_decap_8
XFILLER_59_552 VDD VSS sg13g2_decap_8
XFILLER_47_747 VDD VSS sg13g2_decap_8
XFILLER_74_511 VDD VSS sg13g2_fill_2
XFILLER_86_393 VDD VSS sg13g2_decap_8
XFILLER_62_706 VDD VSS sg13g2_fill_2
XFILLER_74_555 VDD VSS sg13g2_fill_2
XFILLER_34_408 VDD VSS sg13g2_decap_8
XFILLER_36_40 VDD VSS sg13g2_decap_8
XFILLER_36_51 VDD VSS sg13g2_fill_1
XFILLER_14_121 VDD VSS sg13g2_decap_8
XFILLER_15_633 VDD VSS sg13g2_decap_8
XFILLER_27_482 VDD VSS sg13g2_decap_8
XFILLER_42_430 VDD VSS sg13g2_decap_8
XFILLER_61_227 VDD VSS sg13g2_decap_8
XFILLER_14_154 VDD VSS sg13g2_decap_8
XFILLER_15_699 VDD VSS sg13g2_decap_8
XFILLER_30_647 VDD VSS sg13g2_decap_4
XFILLER_11_850 VDD VSS sg13g2_decap_8
XFILLER_11_894 VDD VSS sg13g2_decap_8
XFILLER_7_865 VDD VSS sg13g2_decap_8
XFILLER_109_771 VDD VSS sg13g2_fill_1
XFILLER_115_218 VDD VSS sg13g2_decap_8
XFILLER_6_375 VDD VSS sg13g2_decap_8
XFILLER_111_402 VDD VSS sg13g2_decap_8
X_2340_ VDD _2340_/Y _2714_/B VSS sg13g2_inv_1
XFILLER_69_327 VDD VSS sg13g2_decap_8
X_2271_ VDD _2271_/Y _4664_/Q VSS sg13g2_inv_1
XFILLER_96_124 VDD VSS sg13g2_decap_8
X_4010_ _4186_/S _4261_/Q _4286_/Q _4311_/Q _4336_/Q _4190_/A1 _4010_/X VDD VSS sg13g2_mux4_1
XFILLER_65_500 VDD VSS sg13g2_decap_8
XFILLER_38_758 VDD VSS sg13g2_decap_8
XFILLER_53_706 VDD VSS sg13g2_decap_8
XFILLER_18_460 VDD VSS sg13g2_decap_8
XFILLER_18_471 VDD VSS sg13g2_fill_2
XFILLER_53_717 VDD VSS sg13g2_fill_1
XFILLER_92_385 VDD VSS sg13g2_fill_1
X_4912_ fanout258/X VSS VDD _4912_/D _4912_/Q clkload7/A sg13g2_dfrbpq_1
XFILLER_61_772 VDD VSS sg13g2_decap_8
XFILLER_21_614 VDD VSS sg13g2_decap_8
XFILLER_33_474 VDD VSS sg13g2_decap_8
XFILLER_60_271 VDD VSS sg13g2_fill_1
X_4843_ fanout275/X VSS VDD _4843_/D _4843_/Q _4954_/CLK sg13g2_dfrbpq_1
X_4774_ fanout247/X VSS VDD _4774_/D _4774_/Q _4904_/CLK sg13g2_dfrbpq_1
X_3725_ _3725_/Y _4942_/D _3725_/B VDD VSS sg13g2_nand2_1
Xclkbuf_leaf_9_clk clkbuf_4_4_0_clk/X _4749_/CLK VDD VSS sg13g2_buf_8
X_3656_ _4749_/Q VDD _3717_/B VSS _4747_/Q _4748_/Q sg13g2_o21ai_1
X_3587_ _4721_/Q _4720_/Q _3587_/C _3587_/D _3603_/D VDD VSS sg13g2_and4_1
X_2607_ _4602_/Q _4603_/Q _2607_/C _3249_/A _3251_/B VDD VSS sg13g2_nor4_1
XFILLER_0_529 VDD VSS sg13g2_decap_8
XFILLER_103_925 VDD VSS sg13g2_fill_1
XFILLER_114_251 VDD VSS sg13g2_fill_1
X_2538_ _2540_/B _2540_/A _2537_/C _2539_/B VDD VSS sg13g2_a21o_1
XFILLER_87_135 VDD VSS sg13g2_fill_2
XFILLER_102_468 VDD VSS sg13g2_fill_2
XFILLER_102_479 VDD VSS sg13g2_decap_8
X_4208_ _4233_/S _4280_/Q _4305_/Q _4330_/Q _4355_/Q _2347_/A _4208_/X VDD VSS sg13g2_mux4_1
X_2469_ _2469_/A _4845_/Q _2469_/Y VDD VSS sg13g2_nor2b_1
XFILLER_29_736 VDD VSS sg13g2_decap_8
XFILLER_68_360 VDD VSS sg13g2_decap_8
XFILLER_69_883 VDD VSS sg13g2_fill_1
XFILLER_96_680 VDD VSS sg13g2_fill_2
XFILLER_84_875 VDD VSS sg13g2_fill_1
X_4139_ _4139_/Y _4139_/B _4218_/B1 VDD VSS sg13g2_nand2b_1
XFILLER_28_279 VDD VSS sg13g2_decap_8
XFILLER_37_780 VDD VSS sg13g2_decap_8
XFILLER_56_588 VDD VSS sg13g2_decap_8
XFILLER_83_385 VDD VSS sg13g2_decap_8
XFILLER_84_886 VDD VSS sg13g2_fill_2
X_4334__392 VDD VSS _4334_/RESET_B sg13g2_tiehi
XFILLER_71_536 VDD VSS sg13g2_decap_8
XFILLER_73_49 VDD VSS sg13g2_decap_8
XFILLER_83_396 VDD VSS sg13g2_fill_2
XFILLER_40_912 VDD VSS sg13g2_decap_8
XFILLER_52_794 VDD VSS sg13g2_decap_8
XFILLER_11_179 VDD VSS sg13g2_decap_8
XFILLER_7_117 VDD VSS sg13g2_fill_2
XFILLER_4_802 VDD VSS sg13g2_decap_8
XFILLER_3_312 VDD VSS sg13g2_fill_1
XFILLER_98_35 VDD VSS sg13g2_fill_1
X_4341__385 VDD VSS _4341_/RESET_B sg13g2_tiehi
XFILLER_4_879 VDD VSS sg13g2_decap_8
XFILLER_94_617 VDD VSS sg13g2_fill_2
Xfanout170 _4841_/Q fanout170/X VDD VSS sg13g2_buf_1
Xfanout181 fanout189/X _4232_/B1 VDD VSS sg13g2_buf_1
Xfanout192 _4231_/A _4233_/S VDD VSS sg13g2_buf_1
XFILLER_87_691 VDD VSS sg13g2_decap_8
XFILLER_47_50 VDD VSS sg13g2_decap_8
XFILLER_75_864 VDD VSS sg13g2_fill_1
XFILLER_62_525 VDD VSS sg13g2_decap_4
XFILLER_90_845 VDD VSS sg13g2_decap_8
XFILLER_31_912 VDD VSS sg13g2_fill_1
XFILLER_62_569 VDD VSS sg13g2_fill_2
XFILLER_97_7 VDD VSS sg13g2_fill_1
XFILLER_30_433 VDD VSS sg13g2_decap_8
XFILLER_116_505 VDD VSS sg13g2_decap_8
XFILLER_7_640 VDD VSS sg13g2_decap_4
X_3510_ _2654_/A VDD _3510_/Y VSS _3513_/B _3507_/B sg13g2_o21ai_1
XFILLER_6_150 VDD VSS sg13g2_decap_8
Xhold607 _4815_/Q VDD VSS _3925_/A sg13g2_dlygate4sd3_1
Xhold618 _4871_/Q VDD VSS _2540_/A sg13g2_dlygate4sd3_1
X_4490_ fanout296/X VSS VDD _4490_/D _4490_/Q _4971_/CLK sg13g2_dfrbpq_1
Xhold629 _2559_/X VDD VSS _4883_/D sg13g2_dlygate4sd3_1
X_3441_ _3471_/B _3443_/C _3441_/A _3441_/Y VDD VSS sg13g2_nand3_1
X_3372_ VDD _3401_/D _3493_/B VSS sg13g2_inv_1
XFILLER_98_912 VDD VSS sg13g2_decap_8
XFILLER_111_210 VDD VSS sg13g2_decap_8
XFILLER_69_102 VDD VSS sg13g2_decap_8
X_2323_ VDD _3415_/B _2323_/A VSS sg13g2_inv_1
XFILLER_88_90 VDD VSS sg13g2_decap_8
Xhold1307 _2799_/Y VDD VSS _4908_/D sg13g2_dlygate4sd3_1
XFILLER_97_455 VDD VSS sg13g2_decap_8
XFILLER_57_319 VDD VSS sg13g2_fill_2
XFILLER_66_831 VDD VSS sg13g2_decap_8
XFILLER_69_179 VDD VSS sg13g2_decap_8
Xhold1318 _4632_/Q VDD VSS _3625_/A1 sg13g2_dlygate4sd3_1
Xhold1329 _4680_/Q VDD VSS _3483_/A sg13g2_dlygate4sd3_1
X_2254_ VDD _3588_/A _3587_/C VSS sg13g2_inv_1
XFILLER_85_628 VDD VSS sg13g2_decap_8
XFILLER_19_0 VDD VSS sg13g2_decap_8
XFILLER_93_650 VDD VSS sg13g2_decap_8
XFILLER_26_706 VDD VSS sg13g2_fill_2
XFILLER_26_717 VDD VSS sg13g2_decap_8
XFILLER_26_728 VDD VSS sg13g2_fill_2
XFILLER_38_566 VDD VSS sg13g2_decap_8
XFILLER_38_588 VDD VSS sg13g2_decap_8
XFILLER_81_856 VDD VSS sg13g2_decap_8
XFILLER_40_208 VDD VSS sg13g2_decap_8
XFILLER_80_377 VDD VSS sg13g2_decap_8
XFILLER_34_783 VDD VSS sg13g2_decap_8
XFILLER_21_455 VDD VSS sg13g2_decap_8
X_4826_ _2849_/C VSS VDD _4826_/D _4826_/Q _4965_/CLK sg13g2_dfrbpq_1
X_4757_ fanout257/X VSS VDD _4757_/D _4757_/Q _4907_/CLK sg13g2_dfrbpq_1
X_4688_ fanout325/X VSS VDD _4688_/D _4688_/Q _4868_/CLK sg13g2_dfrbpq_1
X_3708_ _3708_/Y _4737_/Q _3708_/B VDD VSS sg13g2_nand2_1
X_3639_ _3688_/A _3718_/A _3639_/X VDD VSS sg13g2_and2_1
XFILLER_103_711 VDD VSS sg13g2_decap_4
XFILLER_0_326 VDD VSS sg13g2_decap_8
XFILLER_1_838 VDD VSS sg13g2_decap_8
XFILLER_88_433 VDD VSS sg13g2_decap_8
XFILLER_102_232 VDD VSS sg13g2_fill_2
XFILLER_102_243 VDD VSS sg13g2_decap_8
XFILLER_103_766 VDD VSS sg13g2_decap_4
XFILLER_88_444 VDD VSS sg13g2_fill_2
XFILLER_75_105 VDD VSS sg13g2_decap_4
XFILLER_75_149 VDD VSS sg13g2_decap_8
XFILLER_56_352 VDD VSS sg13g2_decap_8
XFILLER_56_363 VDD VSS sg13g2_fill_2
XFILLER_57_886 VDD VSS sg13g2_fill_1
XFILLER_72_801 VDD VSS sg13g2_decap_4
XFILLER_17_739 VDD VSS sg13g2_decap_8
XFILLER_56_396 VDD VSS sg13g2_decap_4
XFILLER_71_322 VDD VSS sg13g2_decap_8
XFILLER_71_333 VDD VSS sg13g2_fill_2
XFILLER_17_75 VDD VSS sg13g2_decap_8
XFILLER_17_86 VDD VSS sg13g2_fill_2
XFILLER_44_558 VDD VSS sg13g2_decap_8
XFILLER_24_271 VDD VSS sg13g2_decap_4
XFILLER_25_783 VDD VSS sg13g2_fill_1
XFILLER_31_219 VDD VSS sg13g2_decap_8
XFILLER_9_905 VDD VSS sg13g2_decap_8
XFILLER_12_477 VDD VSS sg13g2_decap_8
XFILLER_40_786 VDD VSS sg13g2_decap_8
XFILLER_8_426 VDD VSS sg13g2_decap_8
XFILLER_33_96 VDD VSS sg13g2_decap_8
XFILLER_4_643 VDD VSS sg13g2_fill_2
XFILLER_113_519 VDD VSS sg13g2_decap_8
XFILLER_3_131 VDD VSS sg13g2_fill_1
XFILLER_4_676 VDD VSS sg13g2_decap_8
X_4419__507 VDD VSS _4419_/RESET_B sg13g2_tiehi
XFILLER_0_893 VDD VSS sg13g2_decap_8
XFILLER_66_105 VDD VSS sg13g2_decap_4
XFILLER_79_477 VDD VSS sg13g2_decap_8
XFILLER_94_403 VDD VSS sg13g2_fill_1
XFILLER_12_7 VDD VSS sg13g2_decap_8
XFILLER_48_864 VDD VSS sg13g2_decap_8
XFILLER_47_363 VDD VSS sg13g2_decap_4
XFILLER_63_856 VDD VSS sg13g2_decap_8
XFILLER_90_631 VDD VSS sg13g2_decap_8
XFILLER_74_92 VDD VSS sg13g2_decap_8
X_3990_ _3989_/Y VDD _3990_/Y VSS _4003_/B _3988_/Y sg13g2_o21ai_1
XFILLER_90_675 VDD VSS sg13g2_decap_8
XFILLER_90_653 VDD VSS sg13g2_fill_2
XFILLER_15_271 VDD VSS sg13g2_decap_8
XFILLER_50_539 VDD VSS sg13g2_decap_8
XFILLER_62_388 VDD VSS sg13g2_decap_8
X_2941_ hold860/X _3096_/A0 _2949_/S _2941_/X VDD VSS sg13g2_mux2_1
XFILLER_31_775 VDD VSS sg13g2_fill_1
X_4611_ fanout281/X VSS VDD _4611_/D _4611_/Q _4619_/CLK sg13g2_dfrbpq_1
X_2872_ _2872_/A0 _3107_/A0 _2875_/S _4307_/D VDD VSS sg13g2_mux2_1
XFILLER_30_274 VDD VSS sg13g2_decap_8
X_4542_ fanout263/X VSS VDD _4542_/D _4542_/Q clkload5/A sg13g2_dfrbpq_1
XFILLER_116_324 VDD VSS sg13g2_decap_8
XFILLER_7_481 VDD VSS sg13g2_decap_8
X_4473_ fanout302/X VSS VDD _4473_/D _4473_/Q _4884_/CLK sg13g2_dfrbpq_1
X_3424_ _3424_/A _3424_/B _3424_/C _3425_/C VDD VSS sg13g2_or3_1
XFILLER_112_530 VDD VSS sg13g2_fill_2
XFILLER_112_541 VDD VSS sg13g2_decap_4
X_3355_ VSS VDD _3357_/A _3353_/A _3355_/Y _3354_/Y sg13g2_a21oi_1
XFILLER_97_230 VDD VSS sg13g2_decap_8
Xhold1104 _4562_/Q VDD VSS _2503_/C sg13g2_dlygate4sd3_1
Xhold1115 _4471_/Q VDD VSS _3532_/A1 sg13g2_dlygate4sd3_1
X_3286_ _3286_/Y _3286_/A _3286_/B VDD VSS sg13g2_xnor2_1
X_2306_ VDD _2615_/A _3265_/B VSS sg13g2_inv_1
XFILLER_100_769 VDD VSS sg13g2_fill_1
XFILLER_57_127 VDD VSS sg13g2_fill_2
Xhold1126 _4477_/Q VDD VSS _3538_/A1 sg13g2_dlygate4sd3_1
Xhold1137 _4508_/Q VDD VSS _3084_/A1 sg13g2_dlygate4sd3_1
Xhold1148 _4299_/Q VDD VSS _2864_/A0 sg13g2_dlygate4sd3_1
X_2237_ VDD _2470_/A input3/X VSS sg13g2_inv_1
XFILLER_97_296 VDD VSS sg13g2_decap_8
XFILLER_85_436 VDD VSS sg13g2_decap_8
XFILLER_39_864 VDD VSS sg13g2_decap_8
XFILLER_54_812 VDD VSS sg13g2_decap_8
Xhold1159 _2962_/X VDD VSS _4391_/D sg13g2_dlygate4sd3_1
XFILLER_54_834 VDD VSS sg13g2_fill_2
XFILLER_54_889 VDD VSS sg13g2_decap_8
XFILLER_81_653 VDD VSS sg13g2_decap_8
X_4331__395 VDD VSS _4331_/RESET_B sg13g2_tiehi
XFILLER_110_35 VDD VSS sg13g2_decap_8
XFILLER_13_208 VDD VSS sg13g2_fill_2
XFILLER_13_219 VDD VSS sg13g2_decap_8
XFILLER_34_580 VDD VSS sg13g2_decap_4
X_4809_ fanout288/X VSS VDD _4809_/D _4809_/Q _4927_/CLK sg13g2_dfrbpq_1
XFILLER_108_836 VDD VSS sg13g2_decap_8
XFILLER_79_48 VDD VSS sg13g2_decap_8
XFILLER_0_112 VDD VSS sg13g2_decap_8
XFILLER_116_880 VDD VSS sg13g2_decap_8
Xhold960 _4342_/Q VDD VSS hold960/X sg13g2_dlygate4sd3_1
Xhold971 _4447_/Q VDD VSS hold971/X sg13g2_dlygate4sd3_1
Xhold982 _4600_/Q VDD VSS _2603_/B sg13g2_dlygate4sd3_1
XFILLER_89_742 VDD VSS sg13g2_decap_8
Xhold993 _4504_/Q VDD VSS hold993/X sg13g2_dlygate4sd3_1
XFILLER_95_14 VDD VSS sg13g2_decap_8
XFILLER_103_574 VDD VSS sg13g2_decap_4
XFILLER_88_263 VDD VSS sg13g2_decap_8
XFILLER_0_189 VDD VSS sg13g2_decap_8
XFILLER_76_447 VDD VSS sg13g2_decap_8
XFILLER_29_352 VDD VSS sg13g2_decap_8
XFILLER_63_108 VDD VSS sg13g2_decap_8
XFILLER_63_119 VDD VSS sg13g2_fill_1
Xhold1660 _3849_/Y VDD VSS _4790_/D sg13g2_dlygate4sd3_1
Xhold1671 _3841_/B VDD VSS _3839_/A1 sg13g2_dlygate4sd3_1
XFILLER_17_536 VDD VSS sg13g2_decap_8
XFILLER_57_683 VDD VSS sg13g2_decap_8
Xhold1682 _4953_/Q VDD VSS _2464_/A sg13g2_dlygate4sd3_1
XFILLER_60_804 VDD VSS sg13g2_fill_1
XFILLER_60_815 VDD VSS sg13g2_decap_8
XFILLER_71_141 VDD VSS sg13g2_fill_2
XFILLER_72_664 VDD VSS sg13g2_decap_8
XFILLER_32_528 VDD VSS sg13g2_decap_8
XFILLER_44_84 VDD VSS sg13g2_decap_8
XFILLER_71_196 VDD VSS sg13g2_decap_8
XFILLER_13_775 VDD VSS sg13g2_decap_8
XFILLER_8_223 VDD VSS sg13g2_decap_8
XFILLER_5_78 VDD VSS sg13g2_decap_8
XFILLER_79_230 VDD VSS sg13g2_fill_1
X_3140_ _3140_/Y _3140_/A _3140_/B VDD VSS sg13g2_nand2_1
XFILLER_0_690 VDD VSS sg13g2_decap_8
XFILLER_67_447 VDD VSS sg13g2_fill_2
X_3071_ _3070_/Y VDD _3071_/Y VSS _2353_/Y _3079_/S sg13g2_o21ai_1
XFILLER_85_80 VDD VSS sg13g2_decap_8
XFILLER_35_322 VDD VSS sg13g2_fill_2
XFILLER_36_823 VDD VSS sg13g2_decap_8
XFILLER_51_815 VDD VSS sg13g2_fill_2
XFILLER_51_837 VDD VSS sg13g2_decap_8
X_3973_ hold807/X VDD _3973_/Y VSS _2634_/B _3972_/C sg13g2_o21ai_1
XFILLER_31_550 VDD VSS sg13g2_decap_8
X_2924_ _2924_/A0 _3106_/A0 _2927_/S _4356_/D VDD VSS sg13g2_mux2_1
XFILLER_86_0 VDD VSS sg13g2_decap_8
X_2855_ _2855_/A0 _3090_/A0 _2875_/S _2855_/X VDD VSS sg13g2_mux2_1
X_4525_ fanout312/X VSS VDD _4525_/D _4525_/Q _4961_/CLK sg13g2_dfrbpq_1
X_2786_ _4870_/D _2786_/B _4867_/D VDD VSS sg13g2_nor2_1
XFILLER_116_165 VDD VSS sg13g2_decap_8
X_4456_ _4456_/RESET_B VSS VDD _4456_/D _4456_/Q _4976_/CLK sg13g2_dfrbpq_1
X_4387_ _4387_/RESET_B VSS VDD _4387_/D _4387_/Q _4959_/CLK sg13g2_dfrbpq_1
X_3407_ VSS VDD _3425_/A _3407_/B _3407_/A sg13g2_or2_1
XFILLER_85_200 VDD VSS sg13g2_fill_2
X_3338_ _4790_/Q VDD _3339_/B VSS _4789_/Q _4788_/Q sg13g2_o21ai_1
XFILLER_105_35 VDD VSS sg13g2_fill_2
XFILLER_100_566 VDD VSS sg13g2_decap_8
XFILLER_65_28 VDD VSS sg13g2_decap_8
X_3269_ _3281_/A _3269_/B _4613_/D VDD VSS sg13g2_nor2_1
XFILLER_86_778 VDD VSS sg13g2_fill_1
XFILLER_38_160 VDD VSS sg13g2_fill_2
XFILLER_66_480 VDD VSS sg13g2_decap_8
XFILLER_42_804 VDD VSS sg13g2_decap_8
XFILLER_26_388 VDD VSS sg13g2_decap_8
XFILLER_53_174 VDD VSS sg13g2_fill_1
XFILLER_54_697 VDD VSS sg13g2_fill_1
XFILLER_81_483 VDD VSS sg13g2_fill_1
XFILLER_81_38 VDD VSS sg13g2_decap_8
X_4409__517 VDD VSS _4409_/RESET_B sg13g2_tiehi
XFILLER_14_21 VDD VSS sg13g2_fill_2
XFILLER_10_734 VDD VSS sg13g2_fill_1
XFILLER_50_892 VDD VSS sg13g2_fill_1
XFILLER_5_237 VDD VSS sg13g2_decap_4
XFILLER_6_749 VDD VSS sg13g2_decap_8
XFILLER_107_132 VDD VSS sg13g2_decap_8
XFILLER_2_911 VDD VSS sg13g2_decap_8
XFILLER_30_97 VDD VSS sg13g2_decap_8
Xhold790 _4481_/Q VDD VSS hold790/X sg13g2_dlygate4sd3_1
XFILLER_1_465 VDD VSS sg13g2_decap_8
XFILLER_49_403 VDD VSS sg13g2_decap_8
XFILLER_77_701 VDD VSS sg13g2_decap_8
XFILLER_49_447 VDD VSS sg13g2_fill_1
XFILLER_49_458 VDD VSS sg13g2_decap_8
XFILLER_65_918 VDD VSS sg13g2_decap_8
XFILLER_76_277 VDD VSS sg13g2_decap_8
Xclkbuf_4_3_0_clk clkbuf_0_clk/X clkbuf_4_3_0_clk/X VDD VSS sg13g2_buf_8
XFILLER_45_642 VDD VSS sg13g2_decap_8
XFILLER_45_653 VDD VSS sg13g2_fill_1
Xhold1490 _4570_/Q VDD VSS _3167_/A sg13g2_dlygate4sd3_1
XFILLER_91_258 VDD VSS sg13g2_fill_1
XFILLER_91_247 VDD VSS sg13g2_decap_8
XFILLER_32_336 VDD VSS sg13g2_decap_8
XFILLER_60_645 VDD VSS sg13g2_decap_4
X_2640_ VDD _4845_/D _2640_/A VSS sg13g2_inv_1
X_2571_ _2572_/C _2571_/A _2571_/B VDD VSS sg13g2_nand2_1
XFILLER_5_760 VDD VSS sg13g2_decap_8
X_4310_ _4310_/RESET_B VSS VDD _4310_/D _4310_/Q _4959_/CLK sg13g2_dfrbpq_1
XFILLER_99_303 VDD VSS sg13g2_decap_8
XFILLER_114_669 VDD VSS sg13g2_fill_1
X_4241_ _4241_/B1 VDD _4241_/Y VSS _4241_/A1 _4459_/Q sg13g2_o21ai_1
XFILLER_113_168 VDD VSS sg13g2_decap_8
XFILLER_56_907 VDD VSS sg13g2_decap_8
X_4172_ _4242_/S _4277_/Q _4172_/A1 _4327_/Q _4352_/Q _4172_/S1 _4172_/X VDD VSS sg13g2_mux4_1
XFILLER_95_542 VDD VSS sg13g2_decap_4
X_3123_ _4628_/Q hold872/X _3138_/B _3123_/X VDD VSS sg13g2_mux2_1
XFILLER_96_90 VDD VSS sg13g2_fill_2
XFILLER_36_620 VDD VSS sg13g2_decap_8
XFILLER_48_480 VDD VSS sg13g2_fill_2
X_3054_ hold784/X hold914/X _3057_/S _4480_/D VDD VSS sg13g2_mux2_1
XFILLER_82_269 VDD VSS sg13g2_decap_8
XFILLER_35_163 VDD VSS sg13g2_decap_8
XFILLER_36_697 VDD VSS sg13g2_decap_8
XFILLER_51_612 VDD VSS sg13g2_decap_4
XFILLER_50_155 VDD VSS sg13g2_decap_8
XFILLER_51_689 VDD VSS sg13g2_decap_8
X_3956_ _3956_/A _3956_/B _3956_/Y VDD VSS sg13g2_nor2_1
XFILLER_32_892 VDD VSS sg13g2_fill_1
X_2907_ _2907_/A0 _3089_/A0 _2927_/S _2907_/X VDD VSS sg13g2_mux2_1
XFILLER_109_408 VDD VSS sg13g2_decap_8
XFILLER_31_391 VDD VSS sg13g2_decap_8
X_3887_ VSS VDD _4805_/D _3887_/B _3887_/A sg13g2_or2_1
X_2838_ _2838_/A0 _3100_/A0 _2846_/S _2838_/X VDD VSS sg13g2_mux2_1
X_2769_ VSS VDD _2760_/B _2771_/C _2769_/Y _2768_/Y sg13g2_a21oi_1
XFILLER_105_614 VDD VSS sg13g2_decap_8
X_4508_ fanout308/X VSS VDD _4508_/D _4508_/Q _4978_/CLK sg13g2_dfrbpq_1
X_4439_ _4439_/RESET_B VSS VDD _4439_/D _4439_/Q clkload9/A sg13g2_dfrbpq_1
XFILLER_104_168 VDD VSS sg13g2_fill_1
XFILLER_116_56 VDD VSS sg13g2_decap_8
XFILLER_98_391 VDD VSS sg13g2_decap_4
XFILLER_100_341 VDD VSS sg13g2_decap_8
XFILLER_59_767 VDD VSS sg13g2_decap_8
XFILLER_100_385 VDD VSS sg13g2_fill_1
XFILLER_86_597 VDD VSS sg13g2_decap_4
XFILLER_73_269 VDD VSS sg13g2_decap_8
XFILLER_27_686 VDD VSS sg13g2_decap_8
XFILLER_42_601 VDD VSS sg13g2_decap_8
XFILLER_82_781 VDD VSS sg13g2_decap_8
XFILLER_14_347 VDD VSS sg13g2_decap_8
XFILLER_25_42 VDD VSS sg13g2_decap_8
XFILLER_81_291 VDD VSS sg13g2_decap_8
XFILLER_30_829 VDD VSS sg13g2_decap_8
XFILLER_42_667 VDD VSS sg13g2_decap_8
XFILLER_41_177 VDD VSS sg13g2_decap_4
XFILLER_109_920 VDD VSS sg13g2_decap_4
XFILLER_110_105 VDD VSS sg13g2_decap_8
XFILLER_1_240 VDD VSS sg13g2_fill_2
XFILLER_2_785 VDD VSS sg13g2_decap_8
XFILLER_2_35 VDD VSS sg13g2_decap_8
XFILLER_77_542 VDD VSS sg13g2_decap_8
XFILLER_89_380 VDD VSS sg13g2_decap_8
XFILLER_37_406 VDD VSS sg13g2_decap_4
XFILLER_38_918 VDD VSS sg13g2_decap_8
XFILLER_92_501 VDD VSS sg13g2_decap_8
XFILLER_92_545 VDD VSS sg13g2_decap_8
XFILLER_17_141 VDD VSS sg13g2_decap_8
XFILLER_61_921 VDD VSS sg13g2_decap_4
XFILLER_32_133 VDD VSS sg13g2_decap_8
XFILLER_82_92 VDD VSS sg13g2_fill_1
X_4790_ fanout248/X VSS VDD _4790_/D _4790_/Q clkload2/A sg13g2_dfrbpq_1
X_3810_ _3810_/Y _3837_/B1 _3809_/Y _3837_/A2 _2327_/Y VDD VSS sg13g2_a22oi_1
XFILLER_20_328 VDD VSS sg13g2_decap_8
X_3741_ _3739_/Y VDD _3741_/Y VSS _3766_/A1 _3740_/X sg13g2_o21ai_1
X_3672_ _4745_/Q VDD _3674_/B VSS _4743_/Q _4744_/Q sg13g2_o21ai_1
XFILLER_115_901 VDD VSS sg13g2_decap_8
X_2623_ VSS VDD _2756_/B _4899_/Q _4900_/Q sg13g2_or2_1
X_2554_ _2556_/C _2554_/B _2554_/Y VDD VSS sg13g2_nor2_1
XFILLER_49_0 VDD VSS sg13g2_decap_8
XFILLER_99_133 VDD VSS sg13g2_decap_8
X_2485_ _2485_/B _2485_/C _2485_/A _2486_/B VDD VSS _2485_/D sg13g2_nand4_1
XFILLER_88_829 VDD VSS sg13g2_fill_2
XFILLER_101_138 VDD VSS sg13g2_decap_8
XFILLER_102_639 VDD VSS sg13g2_decap_8
X_4224_ _4227_/A1 VDD _4224_/Y VSS _4222_/Y _4223_/Y sg13g2_o21ai_1
XFILLER_110_650 VDD VSS sg13g2_fill_2
XFILLER_29_918 VDD VSS sg13g2_decap_8
XFILLER_68_564 VDD VSS sg13g2_fill_2
X_4155_ _4233_/S _4275_/Q _4300_/Q _4325_/Q _4350_/Q _2347_/A _4155_/X VDD VSS sg13g2_mux4_1
XFILLER_96_884 VDD VSS sg13g2_decap_8
XFILLER_110_683 VDD VSS sg13g2_decap_8
XFILLER_56_726 VDD VSS sg13g2_decap_8
XFILLER_83_523 VDD VSS sg13g2_fill_1
X_3106_ _3106_/A0 _3134_/A _3109_/S _4530_/D VDD VSS sg13g2_mux2_1
XFILLER_83_545 VDD VSS sg13g2_decap_8
X_4086_ VSS VDD _4244_/A1 _4084_/X _4086_/Y _4085_/Y sg13g2_a21oi_1
XFILLER_102_14 VDD VSS sg13g2_decap_8
XFILLER_70_217 VDD VSS sg13g2_decap_8
X_3037_ hold802/X hold869/X _3057_/S _4463_/D VDD VSS sg13g2_mux2_1
XFILLER_63_280 VDD VSS sg13g2_decap_8
XFILLER_24_678 VDD VSS sg13g2_decap_8
X_3939_ _4816_/Q _3939_/C _4817_/Q _3939_/Y VDD VSS _3939_/D sg13g2_nand4_1
XFILLER_109_216 VDD VSS sg13g2_decap_8
XFILLER_20_884 VDD VSS sg13g2_fill_2
XFILLER_106_923 VDD VSS sg13g2_fill_2
XFILLER_11_55 VDD VSS sg13g2_fill_1
XFILLER_105_444 VDD VSS sg13g2_fill_2
XFILLER_105_455 VDD VSS sg13g2_decap_8
XFILLER_78_306 VDD VSS sg13g2_fill_1
Xfanout330 fanout331/X fanout330/X VDD VSS sg13g2_buf_1
XFILLER_59_542 VDD VSS sg13g2_fill_1
XFILLER_86_372 VDD VSS sg13g2_decap_8
XFILLER_100_193 VDD VSS sg13g2_decap_8
XFILLER_74_534 VDD VSS sg13g2_fill_2
XFILLER_74_567 VDD VSS sg13g2_decap_4
XFILLER_15_601 VDD VSS sg13g2_decap_4
XFILLER_43_910 VDD VSS sg13g2_decap_8
XFILLER_55_781 VDD VSS sg13g2_decap_8
XFILLER_74_589 VDD VSS sg13g2_decap_8
XFILLER_36_85 VDD VSS sg13g2_decap_8
XFILLER_14_133 VDD VSS sg13g2_decap_8
XFILLER_70_773 VDD VSS sg13g2_decap_4
XFILLER_30_626 VDD VSS sg13g2_decap_8
XFILLER_52_84 VDD VSS sg13g2_decap_4
XFILLER_10_350 VDD VSS sg13g2_decap_8
XFILLER_11_873 VDD VSS sg13g2_decap_8
XFILLER_7_811 VDD VSS sg13g2_decap_4
XFILLER_116_709 VDD VSS sg13g2_decap_4
XFILLER_6_332 VDD VSS sg13g2_decap_8
XFILLER_6_343 VDD VSS sg13g2_fill_2
XFILLER_7_844 VDD VSS sg13g2_decap_8
XFILLER_109_783 VDD VSS sg13g2_decap_8
XFILLER_6_354 VDD VSS sg13g2_decap_8
XFILLER_108_293 VDD VSS sg13g2_decap_4
XFILLER_2_560 VDD VSS sg13g2_decap_4
XFILLER_42_7 VDD VSS sg13g2_decap_8
XFILLER_69_306 VDD VSS sg13g2_decap_8
XFILLER_111_436 VDD VSS sg13g2_decap_8
X_2270_ VDD _2270_/Y _3433_/A VSS sg13g2_inv_1
XFILLER_97_637 VDD VSS sg13g2_fill_2
XFILLER_111_469 VDD VSS sg13g2_decap_8
XFILLER_78_884 VDD VSS sg13g2_fill_2
XFILLER_37_236 VDD VSS sg13g2_decap_4
XFILLER_65_556 VDD VSS sg13g2_decap_8
XFILLER_77_394 VDD VSS sg13g2_fill_2
XFILLER_92_320 VDD VSS sg13g2_decap_4
XFILLER_37_258 VDD VSS sg13g2_decap_8
XFILLER_52_206 VDD VSS sg13g2_decap_8
XFILLER_93_876 VDD VSS sg13g2_fill_2
XFILLER_45_280 VDD VSS sg13g2_fill_2
XFILLER_80_548 VDD VSS sg13g2_fill_1
X_4911_ fanout258/X VSS VDD _4911_/D _4911_/Q clkload7/A sg13g2_dfrbpq_1
XFILLER_33_453 VDD VSS sg13g2_decap_8
XFILLER_60_250 VDD VSS sg13g2_decap_8
X_4842_ fanout276/X VSS VDD _4842_/D _4842_/Q _4954_/CLK sg13g2_dfrbpq_1
X_4773_ fanout247/X VSS VDD _4773_/D _4773_/Q _4904_/CLK sg13g2_dfrbpq_1
X_3724_ _3719_/A VDD _3725_/B VSS _3700_/C _3674_/B sg13g2_o21ai_1
XFILLER_9_170 VDD VSS sg13g2_decap_8
X_3655_ _4747_/Q _4748_/Q _3707_/C VDD VSS sg13g2_nor2_1
X_2606_ _4602_/Q _4603_/Q _2607_/C _3249_/B VDD VSS sg13g2_nor3_1
X_3586_ _3586_/Y _3587_/C _3601_/B VDD VSS sg13g2_nand2_1
XFILLER_0_508 VDD VSS sg13g2_decap_8
X_2537_ _2540_/B _2537_/C _2540_/A _2541_/B VDD VSS sg13g2_nand3_1
XFILLER_115_797 VDD VSS sg13g2_decap_8
X_2468_ VDD _4850_/D _3083_/S VSS sg13g2_inv_1
XFILLER_87_114 VDD VSS sg13g2_decap_8
X_4207_ VSS VDD _4244_/A1 _4203_/X _4207_/Y _4206_/Y sg13g2_a21oi_1
XFILLER_29_715 VDD VSS sg13g2_decap_8
X_2399_ _2398_/Y VDD _2399_/Y VSS _4919_/Q _2397_/Y sg13g2_o21ai_1
XFILLER_29_759 VDD VSS sg13g2_fill_1
XFILLER_56_545 VDD VSS sg13g2_decap_4
XFILLER_84_854 VDD VSS sg13g2_decap_8
X_4138_ _4218_/B1 VDD _4138_/Y VSS _4243_/B1 _4137_/X sg13g2_o21ai_1
XFILLER_28_258 VDD VSS sg13g2_decap_8
XFILLER_56_567 VDD VSS sg13g2_decap_8
XFILLER_71_515 VDD VSS sg13g2_decap_8
XFILLER_73_28 VDD VSS sg13g2_decap_8
XFILLER_83_364 VDD VSS sg13g2_decap_8
X_4069_ _4226_/S1 VDD _4069_/Y VSS _4250_/A1 _4342_/Q sg13g2_o21ai_1
XFILLER_36_280 VDD VSS sg13g2_decap_8
XFILLER_12_626 VDD VSS sg13g2_fill_2
XFILLER_12_637 VDD VSS sg13g2_decap_4
XFILLER_52_773 VDD VSS sg13g2_decap_8
XFILLER_11_125 VDD VSS sg13g2_decap_4
XFILLER_8_619 VDD VSS sg13g2_decap_8
XFILLER_11_158 VDD VSS sg13g2_decap_8
XFILLER_4_858 VDD VSS sg13g2_decap_8
XFILLER_106_775 VDD VSS sg13g2_fill_1
XFILLER_3_346 VDD VSS sg13g2_decap_8
XFILLER_79_604 VDD VSS sg13g2_decap_8
XFILLER_105_263 VDD VSS sg13g2_decap_8
XFILLER_105_274 VDD VSS sg13g2_fill_1
XFILLER_66_309 VDD VSS sg13g2_fill_1
XFILLER_47_523 VDD VSS sg13g2_decap_8
XFILLER_59_350 VDD VSS sg13g2_fill_2
XFILLER_75_832 VDD VSS sg13g2_fill_1
Xfanout160 _4848_/Q _4245_/B1 VDD VSS sg13g2_buf_1
Xfanout171 _4840_/Q _4004_/A VDD VSS sg13g2_buf_1
Xfanout182 fanout189/X _4172_/S1 VDD VSS sg13g2_buf_1
XFILLER_87_670 VDD VSS sg13g2_decap_8
XFILLER_47_534 VDD VSS sg13g2_fill_1
Xfanout193 _4242_/S _4231_/A VDD VSS sg13g2_buf_1
XFILLER_86_191 VDD VSS sg13g2_fill_1
XFILLER_16_921 VDD VSS sg13g2_decap_4
XFILLER_74_386 VDD VSS sg13g2_decap_8
XFILLER_43_751 VDD VSS sg13g2_fill_1
XFILLER_15_464 VDD VSS sg13g2_decap_8
XFILLER_30_412 VDD VSS sg13g2_decap_8
XFILLER_42_250 VDD VSS sg13g2_decap_8
XFILLER_42_261 VDD VSS sg13g2_fill_2
XFILLER_42_272 VDD VSS sg13g2_decap_8
XFILLER_43_795 VDD VSS sg13g2_decap_8
XFILLER_70_581 VDD VSS sg13g2_decap_8
XFILLER_8_56 VDD VSS sg13g2_decap_8
Xhold608 _3926_/Y VDD VSS _4815_/D sg13g2_dlygate4sd3_1
Xhold619 _4624_/Q VDD VSS _3294_/A sg13g2_dlygate4sd3_1
X_3440_ _3439_/Y VDD _4657_/D VSS _2274_/Y _3475_/C sg13g2_o21ai_1
X_3371_ _4648_/Q _4647_/Q _3493_/B VDD VSS sg13g2_nor2b_1
XFILLER_3_891 VDD VSS sg13g2_decap_8
X_2322_ VDD _3411_/B _2322_/A VSS sg13g2_inv_1
XFILLER_97_434 VDD VSS sg13g2_decap_8
XFILLER_100_918 VDD VSS sg13g2_decap_8
XFILLER_112_767 VDD VSS sg13g2_fill_1
XFILLER_69_158 VDD VSS sg13g2_decap_8
XFILLER_85_607 VDD VSS sg13g2_decap_8
XFILLER_111_266 VDD VSS sg13g2_decap_8
XFILLER_66_810 VDD VSS sg13g2_decap_8
XFILLER_84_128 VDD VSS sg13g2_fill_2
Xhold1308 _4590_/Q VDD VSS _3213_/A sg13g2_dlygate4sd3_1
Xhold1319 _4953_/Q VDD VSS _2751_/A sg13g2_dlygate4sd3_1
X_2253_ VDD _2651_/A _4721_/Q VSS sg13g2_inv_1
XFILLER_77_180 VDD VSS sg13g2_decap_8
XFILLER_65_353 VDD VSS sg13g2_fill_1
XFILLER_19_781 VDD VSS sg13g2_decap_4
XFILLER_53_526 VDD VSS sg13g2_decap_8
XFILLER_92_194 VDD VSS sg13g2_decap_8
XFILLER_80_345 VDD VSS sg13g2_decap_8
XFILLER_21_401 VDD VSS sg13g2_decap_8
X_4825_ fanout314/X VSS VDD _4825_/D _4825_/Q _4965_/CLK sg13g2_dfrbpq_1
X_4756_ fanout269/X VSS VDD _4756_/D _4756_/Q _4841_/CLK sg13g2_dfrbpq_1
XFILLER_107_506 VDD VSS sg13g2_decap_8
X_4687_ fanout310/X VSS VDD _4687_/D _4687_/Q _4869_/CLK sg13g2_dfrbpq_1
X_3707_ _4749_/Q _3707_/C _3717_/A _3707_/Y VDD VSS sg13g2_nand3_1
X_3638_ VSS VDD _3627_/Y _3698_/C _3642_/A _3718_/A sg13g2_a21oi_1
XFILLER_1_817 VDD VSS sg13g2_decap_8
X_3569_ _3601_/B _3569_/A1 _3568_/Y _3569_/X VDD VSS sg13g2_a21o_1
XFILLER_0_305 VDD VSS sg13g2_decap_8
XFILLER_68_39 VDD VSS sg13g2_decap_8
XFILLER_103_745 VDD VSS sg13g2_decap_8
XFILLER_76_618 VDD VSS sg13g2_fill_2
XFILLER_29_523 VDD VSS sg13g2_decap_8
XFILLER_75_128 VDD VSS sg13g2_decap_8
XFILLER_29_589 VDD VSS sg13g2_decap_8
XFILLER_57_865 VDD VSS sg13g2_decap_8
XFILLER_84_673 VDD VSS sg13g2_decap_8
XFILLER_16_239 VDD VSS sg13g2_decap_8
XFILLER_44_526 VDD VSS sg13g2_decap_8
XFILLER_44_537 VDD VSS sg13g2_decap_8
XFILLER_56_375 VDD VSS sg13g2_decap_8
XFILLER_25_740 VDD VSS sg13g2_decap_8
XFILLER_13_924 VDD VSS sg13g2_fill_2
XFILLER_25_773 VDD VSS sg13g2_fill_1
XFILLER_40_710 VDD VSS sg13g2_decap_8
XFILLER_12_423 VDD VSS sg13g2_fill_1
XFILLER_8_449 VDD VSS sg13g2_fill_1
XFILLER_116_0 VDD VSS sg13g2_decap_8
XFILLER_3_121 VDD VSS sg13g2_fill_1
XFILLER_106_594 VDD VSS sg13g2_decap_8
XFILLER_79_456 VDD VSS sg13g2_decap_8
XFILLER_0_872 VDD VSS sg13g2_decap_8
XFILLER_58_61 VDD VSS sg13g2_decap_8
XFILLER_48_843 VDD VSS sg13g2_decap_8
XFILLER_47_342 VDD VSS sg13g2_decap_8
XFILLER_75_673 VDD VSS sg13g2_decap_8
XFILLER_35_515 VDD VSS sg13g2_decap_8
XFILLER_63_824 VDD VSS sg13g2_decap_8
XFILLER_63_835 VDD VSS sg13g2_fill_1
XFILLER_62_345 VDD VSS sg13g2_fill_2
XFILLER_62_367 VDD VSS sg13g2_decap_8
XFILLER_74_71 VDD VSS sg13g2_decap_8
XFILLER_31_721 VDD VSS sg13g2_decap_8
XFILLER_50_518 VDD VSS sg13g2_decap_8
X_2940_ _2940_/A0 _3095_/A0 _2949_/S _2940_/X VDD VSS sg13g2_mux2_1
XFILLER_31_743 VDD VSS sg13g2_fill_1
XFILLER_31_754 VDD VSS sg13g2_decap_8
X_2871_ _2871_/A0 _3106_/A0 _2875_/S _4306_/D VDD VSS sg13g2_mux2_1
X_4610_ fanout281/X VSS VDD _4610_/D _4610_/Q _4619_/CLK sg13g2_dfrbpq_1
XFILLER_116_303 VDD VSS sg13g2_decap_8
X_4541_ fanout285/X VSS VDD _4541_/D _4541_/Q _4559_/CLK sg13g2_dfrbpq_1
X_4472_ fanout308/X VSS VDD _4472_/D _4472_/Q _4978_/CLK sg13g2_dfrbpq_1
X_3423_ _3493_/A _3423_/B _3423_/X VDD VSS sg13g2_and2_1
XFILLER_31_0 VDD VSS sg13g2_decap_8
X_3354_ _3408_/A VDD _3354_/Y VSS _3357_/A _3353_/A sg13g2_o21ai_1
XFILLER_97_220 VDD VSS sg13g2_fill_2
XFILLER_100_704 VDD VSS sg13g2_decap_8
XFILLER_100_726 VDD VSS sg13g2_decap_8
XFILLER_58_629 VDD VSS sg13g2_decap_8
XFILLER_85_415 VDD VSS sg13g2_decap_8
Xhold1105 _3149_/Y VDD VSS _3151_/A1 sg13g2_dlygate4sd3_1
X_3285_ _3285_/Y _3286_/B _4620_/Q VDD VSS sg13g2_nand2b_1
X_2305_ VDD _2609_/C _2305_/A VSS sg13g2_inv_1
XFILLER_98_798 VDD VSS sg13g2_decap_8
XFILLER_38_331 VDD VSS sg13g2_decap_8
Xhold1116 _3045_/X VDD VSS _4471_/D sg13g2_dlygate4sd3_1
Xhold1127 _3538_/X VDD VSS _4700_/D sg13g2_dlygate4sd3_1
Xhold1138 _4401_/Q VDD VSS _2972_/A0 sg13g2_dlygate4sd3_1
Xhold1149 _2864_/X VDD VSS _4299_/D sg13g2_dlygate4sd3_1
X_2236_ VDD _2236_/Y _2236_/A VSS sg13g2_inv_1
XFILLER_38_353 VDD VSS sg13g2_decap_8
XFILLER_66_673 VDD VSS sg13g2_decap_4
XFILLER_38_397 VDD VSS sg13g2_decap_8
XFILLER_93_481 VDD VSS sg13g2_decap_8
XFILLER_53_334 VDD VSS sg13g2_decap_8
XFILLER_110_14 VDD VSS sg13g2_decap_8
XFILLER_22_710 VDD VSS sg13g2_fill_1
XFILLER_10_916 VDD VSS sg13g2_decap_8
X_4808_ fanout293/X VSS VDD _4808_/D _4808_/Q _4927_/CLK sg13g2_dfrbpq_1
XFILLER_108_815 VDD VSS sg13g2_decap_8
XFILLER_5_408 VDD VSS sg13g2_fill_1
X_4739_ fanout273/X VSS VDD _4739_/D _4739_/Q _4749_/CLK sg13g2_dfrbpq_1
XFILLER_107_314 VDD VSS sg13g2_decap_8
XFILLER_1_625 VDD VSS sg13g2_decap_8
Xhold950 _4455_/Q VDD VSS hold950/X sg13g2_dlygate4sd3_1
Xhold961 _4344_/Q VDD VSS hold961/X sg13g2_dlygate4sd3_1
Xhold972 _3021_/X VDD VSS _4447_/D sg13g2_dlygate4sd3_1
XFILLER_103_553 VDD VSS sg13g2_decap_8
Xhold983 _3236_/Y VDD VSS hold983/X sg13g2_dlygate4sd3_1
Xhold994 _4375_/Q VDD VSS hold994/X sg13g2_dlygate4sd3_1
XFILLER_89_765 VDD VSS sg13g2_fill_1
XFILLER_88_242 VDD VSS sg13g2_decap_8
XFILLER_0_168 VDD VSS sg13g2_decap_8
XFILLER_49_629 VDD VSS sg13g2_decap_8
XFILLER_92_908 VDD VSS sg13g2_decap_8
XFILLER_29_331 VDD VSS sg13g2_decap_8
XFILLER_57_662 VDD VSS sg13g2_decap_8
Xhold1650 _4621_/Q VDD VSS _2605_/B sg13g2_dlygate4sd3_1
Xhold1661 _4785_/Q VDD VSS _2316_/A sg13g2_dlygate4sd3_1
XFILLER_17_515 VDD VSS sg13g2_decap_8
XFILLER_28_86 VDD VSS sg13g2_decap_8
XFILLER_56_161 VDD VSS sg13g2_decap_8
XFILLER_56_172 VDD VSS sg13g2_fill_1
XFILLER_84_492 VDD VSS sg13g2_decap_8
Xhold1672 _3840_/Y VDD VSS _4787_/D sg13g2_dlygate4sd3_1
XFILLER_91_429 VDD VSS sg13g2_decap_8
XFILLER_71_131 VDD VSS sg13g2_fill_2
XFILLER_72_643 VDD VSS sg13g2_fill_2
XFILLER_32_507 VDD VSS sg13g2_decap_8
XFILLER_44_63 VDD VSS sg13g2_decap_8
XFILLER_12_253 VDD VSS sg13g2_fill_1
XFILLER_40_562 VDD VSS sg13g2_decap_8
X_4425__501 VDD VSS _4425_/RESET_B sg13g2_tiehi
XFILLER_9_703 VDD VSS sg13g2_decap_8
XFILLER_12_264 VDD VSS sg13g2_fill_2
XFILLER_12_275 VDD VSS sg13g2_decap_8
XFILLER_40_573 VDD VSS sg13g2_fill_2
XFILLER_9_769 VDD VSS sg13g2_decap_8
XFILLER_60_51 VDD VSS sg13g2_fill_1
XFILLER_60_95 VDD VSS sg13g2_decap_8
XFILLER_4_430 VDD VSS sg13g2_decap_8
XFILLER_107_881 VDD VSS sg13g2_fill_2
XFILLER_5_57 VDD VSS sg13g2_decap_8
XFILLER_94_201 VDD VSS sg13g2_decap_8
XFILLER_67_426 VDD VSS sg13g2_decap_8
X_3070_ _3070_/Y _3070_/A _3079_/S VDD VSS sg13g2_nand2_1
XFILLER_95_735 VDD VSS sg13g2_fill_1
XFILLER_94_212 VDD VSS sg13g2_fill_1
XFILLER_36_802 VDD VSS sg13g2_decap_8
XFILLER_94_256 VDD VSS sg13g2_decap_4
XFILLER_35_301 VDD VSS sg13g2_fill_2
XFILLER_35_356 VDD VSS sg13g2_fill_2
XFILLER_36_879 VDD VSS sg13g2_decap_8
XFILLER_23_507 VDD VSS sg13g2_decap_8
XFILLER_23_518 VDD VSS sg13g2_fill_2
XFILLER_62_175 VDD VSS sg13g2_fill_2
XFILLER_63_687 VDD VSS sg13g2_decap_8
XFILLER_62_186 VDD VSS sg13g2_decap_8
X_3972_ _4828_/Q _3972_/C _3977_/S _3972_/Y VDD VSS _3972_/D sg13g2_nand4_1
XFILLER_90_495 VDD VSS sg13g2_decap_8
X_2923_ _2923_/A0 _3105_/A0 _2926_/S _4355_/D VDD VSS sg13g2_mux2_1
X_2854_ hold952/X _3089_/A0 _2873_/S _2854_/X VDD VSS sg13g2_mux2_1
XFILLER_79_0 VDD VSS sg13g2_decap_8
X_2785_ _2786_/B _2787_/A _2787_/B VDD VSS sg13g2_xnor2_1
X_4524_ fanout297/X VSS VDD _4524_/D _4524_/Q _4966_/CLK sg13g2_dfrbpq_1
XFILLER_116_133 VDD VSS sg13g2_fill_2
XFILLER_116_144 VDD VSS sg13g2_decap_8
X_4455_ _4455_/RESET_B VSS VDD _4455_/D _4455_/Q _4977_/CLK sg13g2_dfrbpq_1
X_4386_ _4386_/RESET_B VSS VDD _4386_/D _4386_/Q _4729_/CLK sg13g2_dfrbpq_1
X_3406_ _3420_/A _3406_/C _3406_/A _3407_/B VDD VSS _3406_/D sg13g2_nand4_1
X_3337_ _3337_/A _3396_/A _3405_/B _3337_/D _3337_/Y VDD VSS sg13g2_nor4_1
XFILLER_98_584 VDD VSS sg13g2_decap_8
XFILLER_86_713 VDD VSS sg13g2_decap_8
XFILLER_100_545 VDD VSS sg13g2_decap_8
XFILLER_112_372 VDD VSS sg13g2_decap_8
XFILLER_112_383 VDD VSS sg13g2_fill_2
X_3268_ _3269_/B _3268_/A _3268_/B VDD VSS sg13g2_xnor2_1
XFILLER_27_824 VDD VSS sg13g2_fill_2
X_3199_ VSS VDD hold923/X _3198_/Y _3199_/Y _3192_/X sg13g2_a21oi_1
XFILLER_53_131 VDD VSS sg13g2_fill_2
XFILLER_26_367 VDD VSS sg13g2_decap_8
XFILLER_41_348 VDD VSS sg13g2_decap_8
XFILLER_14_33 VDD VSS sg13g2_fill_1
XFILLER_50_871 VDD VSS sg13g2_decap_8
XFILLER_10_713 VDD VSS sg13g2_fill_1
XFILLER_22_573 VDD VSS sg13g2_decap_8
XFILLER_22_584 VDD VSS sg13g2_decap_8
XFILLER_30_21 VDD VSS sg13g2_decap_8
XFILLER_6_728 VDD VSS sg13g2_decap_8
XFILLER_30_76 VDD VSS sg13g2_decap_8
XFILLER_1_422 VDD VSS sg13g2_decap_8
Xhold791 _3542_/X VDD VSS _4704_/D sg13g2_dlygate4sd3_1
Xhold780 _4894_/Q VDD VSS _2584_/A sg13g2_dlygate4sd3_1
XFILLER_104_884 VDD VSS sg13g2_fill_2
XFILLER_103_394 VDD VSS sg13g2_decap_8
XFILLER_76_201 VDD VSS sg13g2_fill_1
XFILLER_76_223 VDD VSS sg13g2_decap_4
XFILLER_39_85 VDD VSS sg13g2_decap_8
XFILLER_39_96 VDD VSS sg13g2_fill_1
XFILLER_76_256 VDD VSS sg13g2_decap_8
XFILLER_64_429 VDD VSS sg13g2_decap_8
XFILLER_92_749 VDD VSS sg13g2_decap_8
XFILLER_44_131 VDD VSS sg13g2_decap_8
Xhold1480 _4639_/Q VDD VSS _3363_/A1 sg13g2_dlygate4sd3_1
Xhold1491 _3167_/Y VDD VSS _3168_/A2 sg13g2_dlygate4sd3_1
XFILLER_91_237 VDD VSS sg13g2_fill_1
XFILLER_44_164 VDD VSS sg13g2_decap_8
XFILLER_72_495 VDD VSS sg13g2_decap_8
XFILLER_9_544 VDD VSS sg13g2_decap_8
XFILLER_72_7 VDD VSS sg13g2_decap_8
XFILLER_9_599 VDD VSS sg13g2_decap_4
X_2570_ VSS VDD _4887_/Q _2569_/B _2570_/Y _2571_/B sg13g2_a21oi_1
XFILLER_4_282 VDD VSS sg13g2_decap_8
X_4240_ _4240_/A _4434_/Q _4240_/Y VDD VSS sg13g2_nor2_1
X_4171_ _4170_/Y VDD _4171_/Y VSS _4168_/Y _4169_/Y sg13g2_o21ai_1
XFILLER_67_234 VDD VSS sg13g2_decap_8
X_4317__409 VDD VSS _4317_/RESET_B sg13g2_tiehi
X_3122_ hold954/X hold948/X _3138_/B _4546_/D VDD VSS sg13g2_mux2_1
XFILLER_110_854 VDD VSS sg13g2_fill_2
XFILLER_55_407 VDD VSS sg13g2_decap_4
XFILLER_68_779 VDD VSS sg13g2_decap_4
XFILLER_27_109 VDD VSS sg13g2_decap_8
XFILLER_83_738 VDD VSS sg13g2_decap_8
X_3053_ _3540_/A1 hold993/X _3056_/S _4479_/D VDD VSS sg13g2_mux2_1
XFILLER_48_492 VDD VSS sg13g2_fill_2
XFILLER_82_248 VDD VSS sg13g2_decap_8
XFILLER_36_676 VDD VSS sg13g2_decap_8
XFILLER_63_451 VDD VSS sg13g2_decap_4
XFILLER_91_771 VDD VSS sg13g2_fill_2
XFILLER_32_860 VDD VSS sg13g2_decap_4
XFILLER_50_145 VDD VSS sg13g2_decap_4
XFILLER_51_668 VDD VSS sg13g2_fill_2
X_3955_ _3955_/A _3959_/B _3955_/Y VDD VSS sg13g2_nor2_1
X_2906_ _2906_/A0 _3088_/A0 _2926_/S _4338_/D VDD VSS sg13g2_mux2_1
X_3886_ _3886_/A _3886_/B _3907_/B _3887_/B VDD VSS sg13g2_nor3_1
X_2837_ hold821/X _3023_/A1 _2846_/S _2837_/X VDD VSS sg13g2_mux2_1
XFILLER_3_709 VDD VSS sg13g2_decap_8
X_2768_ _3528_/A VDD _2768_/Y VSS _2760_/B _2771_/C sg13g2_o21ai_1
X_4507_ fanout301/X VSS VDD _4507_/D _4507_/Q _4974_/CLK sg13g2_dfrbpq_1
X_2699_ _2697_/Y VDD _2699_/Y VSS _2695_/C _2698_/Y sg13g2_o21ai_1
X_4438_ _4438_/RESET_B VSS VDD _4438_/D _4438_/Q _4926_/CLK sg13g2_dfrbpq_1
XFILLER_116_35 VDD VSS sg13g2_decap_8
XFILLER_59_702 VDD VSS sg13g2_fill_2
X_4415__511 VDD VSS _4415_/RESET_B sg13g2_tiehi
X_4369_ _4369_/RESET_B VSS VDD _4369_/D _4369_/Q _4965_/CLK sg13g2_dfrbpq_1
XFILLER_98_370 VDD VSS sg13g2_decap_8
XFILLER_86_521 VDD VSS sg13g2_decap_8
XFILLER_100_320 VDD VSS sg13g2_decap_8
XFILLER_101_865 VDD VSS sg13g2_decap_8
XFILLER_58_234 VDD VSS sg13g2_decap_8
XFILLER_86_543 VDD VSS sg13g2_decap_8
XFILLER_100_364 VDD VSS sg13g2_fill_1
XFILLER_27_610 VDD VSS sg13g2_decap_8
XFILLER_27_621 VDD VSS sg13g2_fill_1
XFILLER_73_226 VDD VSS sg13g2_decap_8
XFILLER_74_727 VDD VSS sg13g2_decap_8
XFILLER_39_492 VDD VSS sg13g2_fill_1
XFILLER_25_21 VDD VSS sg13g2_decap_8
XFILLER_82_760 VDD VSS sg13g2_decap_8
XFILLER_92_49 VDD VSS sg13g2_decap_8
XFILLER_26_175 VDD VSS sg13g2_decap_8
XFILLER_26_197 VDD VSS sg13g2_decap_8
XFILLER_41_123 VDD VSS sg13g2_decap_4
XFILLER_42_624 VDD VSS sg13g2_fill_1
XFILLER_54_495 VDD VSS sg13g2_decap_4
XFILLER_25_65 VDD VSS sg13g2_decap_8
XFILLER_30_808 VDD VSS sg13g2_decap_8
XFILLER_41_156 VDD VSS sg13g2_decap_8
X_4422__504 VDD VSS _4422_/RESET_B sg13g2_tiehi
XFILLER_6_503 VDD VSS sg13g2_decap_8
XFILLER_9_0 VDD VSS sg13g2_decap_8
XFILLER_111_629 VDD VSS sg13g2_decap_8
XFILLER_2_764 VDD VSS sg13g2_decap_8
XFILLER_1_274 VDD VSS sg13g2_fill_2
XFILLER_2_14 VDD VSS sg13g2_decap_8
XFILLER_1_296 VDD VSS sg13g2_decap_8
XFILLER_49_234 VDD VSS sg13g2_decap_4
XFILLER_65_738 VDD VSS sg13g2_decap_8
XFILLER_92_524 VDD VSS sg13g2_fill_1
XFILLER_17_120 VDD VSS sg13g2_decap_8
XFILLER_17_186 VDD VSS sg13g2_decap_8
XFILLER_18_698 VDD VSS sg13g2_decap_8
XFILLER_21_819 VDD VSS sg13g2_decap_8
XFILLER_60_465 VDD VSS sg13g2_fill_1
XFILLER_14_893 VDD VSS sg13g2_decap_8
XFILLER_20_307 VDD VSS sg13g2_decap_8
XFILLER_32_189 VDD VSS sg13g2_decap_8
X_3740_ _3740_/B _3740_/A _3740_/X VDD VSS sg13g2_xor2_1
X_3671_ VDD VSS _3670_/Y _3664_/Y _3680_/B _3698_/C _3671_/Y _3662_/X sg13g2_a221oi_1
X_2622_ _3789_/A _2622_/B _3728_/C VDD VSS sg13g2_nor2_1
XFILLER_114_401 VDD VSS sg13g2_fill_2
X_2553_ VSS VDD _4879_/Q _2550_/B _2553_/Y _2551_/B sg13g2_a21oi_1
XFILLER_99_112 VDD VSS sg13g2_decap_8
XFILLER_88_808 VDD VSS sg13g2_decap_8
X_2484_ _3902_/C _3907_/A _3918_/B _3919_/A _2485_/D VDD VSS sg13g2_nor4_1
XFILLER_101_117 VDD VSS sg13g2_decap_8
X_4223_ _4226_/S1 VDD _4223_/Y VSS _4241_/A1 _4457_/Q sg13g2_o21ai_1
XFILLER_99_189 VDD VSS sg13g2_decap_8
XFILLER_87_329 VDD VSS sg13g2_decap_8
X_4154_ VSS VDD _4244_/A1 _4150_/X _4154_/Y _4153_/Y sg13g2_a21oi_1
XFILLER_96_863 VDD VSS sg13g2_fill_1
XFILLER_68_576 VDD VSS sg13g2_fill_1
X_4085_ _4245_/A1 VDD _4085_/Y VSS _4082_/Y _4083_/Y sg13g2_o21ai_1
X_3105_ _3105_/A0 _3132_/A _3108_/S _4529_/D VDD VSS sg13g2_mux2_1
XFILLER_49_790 VDD VSS sg13g2_decap_4
X_3036_ _4462_/Q _3061_/A1 _3057_/S _3036_/X VDD VSS sg13g2_mux2_1
XFILLER_64_760 VDD VSS sg13g2_decap_8
XFILLER_51_421 VDD VSS sg13g2_decap_4
XFILLER_11_307 VDD VSS sg13g2_fill_2
XFILLER_23_189 VDD VSS sg13g2_fill_2
X_3938_ VSS VDD _3952_/B1 _3937_/Y _3938_/Y _3930_/A sg13g2_a21oi_1
XFILLER_20_863 VDD VSS sg13g2_decap_8
X_3869_ _3930_/A _3929_/A _3948_/C VDD VSS sg13g2_nor2_1
Xclkbuf_4_2_0_clk clkbuf_0_clk/X clkbuf_4_2_0_clk/X VDD VSS sg13g2_buf_8
XFILLER_106_902 VDD VSS sg13g2_decap_8
XFILLER_2_7 VDD VSS sg13g2_decap_8
XFILLER_79_819 VDD VSS sg13g2_decap_8
Xfanout320 fanout337/X fanout320/X VDD VSS sg13g2_buf_1
Xfanout331 fanout336/X fanout331/X VDD VSS sg13g2_buf_1
XFILLER_99_690 VDD VSS sg13g2_decap_8
XFILLER_87_830 VDD VSS sg13g2_decap_8
XFILLER_87_863 VDD VSS sg13g2_decap_8
XFILLER_74_513 VDD VSS sg13g2_fill_1
XFILLER_100_172 VDD VSS sg13g2_decap_8
XFILLER_27_451 VDD VSS sg13g2_decap_8
XFILLER_27_462 VDD VSS sg13g2_fill_1
XFILLER_36_64 VDD VSS sg13g2_decap_8
XFILLER_61_207 VDD VSS sg13g2_decap_4
XFILLER_62_708 VDD VSS sg13g2_fill_1
XFILLER_14_101 VDD VSS sg13g2_decap_4
XFILLER_70_730 VDD VSS sg13g2_decap_8
XFILLER_54_292 VDD VSS sg13g2_decap_8
XFILLER_70_752 VDD VSS sg13g2_decap_8
XFILLER_14_189 VDD VSS sg13g2_decap_8
XFILLER_70_796 VDD VSS sg13g2_decap_8
XFILLER_11_830 VDD VSS sg13g2_fill_2
XFILLER_52_63 VDD VSS sg13g2_decap_4
X_4307__419 VDD VSS _4307_/RESET_B sg13g2_tiehi
XFILLER_52_96 VDD VSS sg13g2_decap_8
XFILLER_7_823 VDD VSS sg13g2_decap_8
XFILLER_10_395 VDD VSS sg13g2_decap_8
XFILLER_97_616 VDD VSS sg13g2_decap_8
XFILLER_78_841 VDD VSS sg13g2_decap_8
XFILLER_78_863 VDD VSS sg13g2_decap_8
XFILLER_37_215 VDD VSS sg13g2_decap_8
XFILLER_77_373 VDD VSS sg13g2_decap_8
XFILLER_93_822 VDD VSS sg13g2_decap_8
XFILLER_65_535 VDD VSS sg13g2_decap_8
XFILLER_92_376 VDD VSS sg13g2_decap_8
XFILLER_80_527 VDD VSS sg13g2_decap_8
X_4910_ fanout258/X VSS VDD _4910_/D _4910_/Q clkload7/A sg13g2_dfrbpq_1
XFILLER_93_81 VDD VSS sg13g2_decap_8
XFILLER_45_292 VDD VSS sg13g2_decap_8
X_4841_ fanout270/X VSS VDD _4841_/D _4841_/Q _4841_/CLK sg13g2_dfrbpq_1
XFILLER_20_104 VDD VSS sg13g2_fill_1
XFILLER_21_649 VDD VSS sg13g2_decap_8
X_4772_ fanout246/X VSS VDD _4772_/D _4772_/Q _4904_/CLK sg13g2_dfrbpq_1
X_4405__521 VDD VSS _4405_/RESET_B sg13g2_tiehi
X_3723_ _3723_/Y _3715_/Y _3722_/Y _3726_/B _3995_/B VDD VSS sg13g2_a22oi_1
X_3654_ _3654_/A0 _4646_/Q _3654_/S _3654_/X VDD VSS sg13g2_mux2_1
XFILLER_61_0 VDD VSS sg13g2_decap_8
X_2605_ _4620_/Q _2605_/B _2618_/A VDD VSS sg13g2_nor2_1
X_3585_ _3600_/A _3585_/B _4721_/D VDD VSS sg13g2_and2_1
XFILLER_115_754 VDD VSS sg13g2_decap_8
XFILLER_115_765 VDD VSS sg13g2_fill_2
X_2536_ _2540_/B _2540_/A _4872_/D VDD VSS sg13g2_xor2_1
XFILLER_102_437 VDD VSS sg13g2_decap_8
X_2467_ _2467_/Y _4846_/Q _4930_/Q VDD VSS sg13g2_nand2_1
XFILLER_102_448 VDD VSS sg13g2_fill_1
XFILLER_69_852 VDD VSS sg13g2_fill_1
X_4206_ _4236_/A1 VDD _4206_/Y VSS _4204_/Y _4205_/Y sg13g2_o21ai_1
XFILLER_87_159 VDD VSS sg13g2_decap_8
XFILLER_87_137 VDD VSS sg13g2_fill_1
XFILLER_69_874 VDD VSS sg13g2_decap_8
XFILLER_69_896 VDD VSS sg13g2_decap_4
XFILLER_84_822 VDD VSS sg13g2_decap_8
X_2398_ _4921_/Q _4920_/Q _2398_/Y VDD VSS sg13g2_nor2_1
XFILLER_113_14 VDD VSS sg13g2_decap_8
XFILLER_56_524 VDD VSS sg13g2_decap_8
XFILLER_83_321 VDD VSS sg13g2_decap_8
XFILLER_83_332 VDD VSS sg13g2_fill_1
X_4412__514 VDD VSS _4412_/RESET_B sg13g2_tiehi
X_4137_ _4240_/A _4273_/Q _4298_/Q _4323_/Q _4348_/Q _4172_/S1 _4137_/X VDD VSS sg13g2_mux4_1
XFILLER_44_719 VDD VSS sg13g2_decap_8
X_4068_ _4222_/A _4317_/Q _4068_/Y VDD VSS sg13g2_nor2_1
XFILLER_25_922 VDD VSS sg13g2_decap_4
XFILLER_43_229 VDD VSS sg13g2_fill_2
X_3019_ hold917/X _4519_/Q _3034_/S _3019_/X VDD VSS sg13g2_mux2_1
XFILLER_64_590 VDD VSS sg13g2_decap_8
XFILLER_11_104 VDD VSS sg13g2_decap_8
XFILLER_11_137 VDD VSS sg13g2_decap_4
XFILLER_12_649 VDD VSS sg13g2_fill_1
XFILLER_7_119 VDD VSS sg13g2_fill_1
XFILLER_22_44 VDD VSS sg13g2_decap_8
XFILLER_22_88 VDD VSS sg13g2_decap_8
XFILLER_3_303 VDD VSS sg13g2_decap_8
XFILLER_4_837 VDD VSS sg13g2_decap_8
XFILLER_98_59 VDD VSS sg13g2_decap_4
XFILLER_78_137 VDD VSS sg13g2_fill_2
Xfanout150 _3110_/S _4856_/D VDD VSS sg13g2_buf_1
Xfanout161 fanout165/X _4078_/A VDD VSS sg13g2_buf_1
Xfanout172 _4245_/A1 _4236_/A1 VDD VSS sg13g2_buf_1
Xfanout183 fanout189/X _4241_/B1 VDD VSS sg13g2_buf_1
XFILLER_94_619 VDD VSS sg13g2_fill_1
XFILLER_47_41 VDD VSS sg13g2_fill_2
XFILLER_75_855 VDD VSS sg13g2_decap_8
Xfanout194 _4242_/S _4240_/A VDD VSS sg13g2_buf_1
XFILLER_93_129 VDD VSS sg13g2_decap_8
XFILLER_90_814 VDD VSS sg13g2_decap_8
XFILLER_62_538 VDD VSS sg13g2_decap_8
XFILLER_103_80 VDD VSS sg13g2_decap_4
XFILLER_103_91 VDD VSS sg13g2_fill_2
XFILLER_15_443 VDD VSS sg13g2_decap_8
XFILLER_27_281 VDD VSS sg13g2_decap_8
XFILLER_43_774 VDD VSS sg13g2_decap_8
XFILLER_42_295 VDD VSS sg13g2_fill_1
XFILLER_11_693 VDD VSS sg13g2_decap_8
XFILLER_10_192 VDD VSS sg13g2_decap_8
XFILLER_7_675 VDD VSS sg13g2_decap_4
Xhold609 _4836_/Q VDD VSS _3997_/A sg13g2_dlygate4sd3_1
X_3370_ _3471_/A _3370_/A1 _3370_/S _4646_/D VDD VSS sg13g2_mux2_1
XFILLER_3_870 VDD VSS sg13g2_decap_8
X_2321_ VDD _3405_/B _2321_/A VSS sg13g2_inv_1
XFILLER_97_413 VDD VSS sg13g2_decap_8
XFILLER_88_70 VDD VSS sg13g2_fill_2
XFILLER_69_137 VDD VSS sg13g2_decap_8
X_2252_ VDD _2705_/A _4847_/D VSS sg13g2_inv_1
XFILLER_78_660 VDD VSS sg13g2_decap_8
XFILLER_84_118 VDD VSS sg13g2_fill_1
Xhold1309 _3213_/Y VDD VSS _3214_/B sg13g2_dlygate4sd3_1
XFILLER_19_760 VDD VSS sg13g2_decap_8
XFILLER_80_302 VDD VSS sg13g2_decap_4
XFILLER_81_836 VDD VSS sg13g2_fill_1
XFILLER_92_173 VDD VSS sg13g2_decap_8
XFILLER_34_730 VDD VSS sg13g2_decap_8
XFILLER_33_251 VDD VSS sg13g2_fill_1
XFILLER_33_262 VDD VSS sg13g2_decap_8
XFILLER_34_763 VDD VSS sg13g2_fill_1
X_4824_ fanout313/X VSS VDD _4824_/D _4824_/Q _4824_/CLK sg13g2_dfrbpq_1
X_4755_ fanout268/X VSS VDD _4755_/D _4755_/Q _4841_/CLK sg13g2_dfrbpq_1
X_3706_ _3706_/A _3718_/B _3706_/X VDD VSS sg13g2_and2_1
XFILLER_107_529 VDD VSS sg13g2_decap_8
X_4686_ fanout310/X VSS VDD _4686_/D _4686_/Q _4869_/CLK sg13g2_dfrbpq_1
X_3637_ _3626_/Y _3635_/B _3636_/Y _4739_/D VDD VSS sg13g2_a21o_1
XFILLER_115_551 VDD VSS sg13g2_decap_8
X_3568_ _3568_/A _3568_/B _3568_/C _3568_/Y VDD VSS sg13g2_nor3_1
XFILLER_115_584 VDD VSS sg13g2_decap_8
X_2519_ _3051_/S _4846_/Q _4847_/Q _4851_/Q _2520_/B VDD VSS sg13g2_nor4_1
X_3499_ _3506_/A _3504_/B _3590_/C VDD VSS sg13g2_nor2_1
XFILLER_29_502 VDD VSS sg13g2_decap_8
XFILLER_57_822 VDD VSS sg13g2_decap_8
XFILLER_69_671 VDD VSS sg13g2_decap_8
XFILLER_68_181 VDD VSS sg13g2_decap_8
XFILLER_29_568 VDD VSS sg13g2_decap_8
XFILLER_44_505 VDD VSS sg13g2_decap_8
XFILLER_84_652 VDD VSS sg13g2_decap_8
XFILLER_16_218 VDD VSS sg13g2_decap_8
XFILLER_17_44 VDD VSS sg13g2_decap_8
XFILLER_72_847 VDD VSS sg13g2_decap_8
XFILLER_83_184 VDD VSS sg13g2_decap_8
XFILLER_17_99 VDD VSS sg13g2_decap_8
XFILLER_37_590 VDD VSS sg13g2_decap_8
XFILLER_71_346 VDD VSS sg13g2_fill_2
XFILLER_13_903 VDD VSS sg13g2_decap_8
XFILLER_71_379 VDD VSS sg13g2_decap_8
XFILLER_24_284 VDD VSS sg13g2_decap_8
XFILLER_33_21 VDD VSS sg13g2_fill_2
XFILLER_12_468 VDD VSS sg13g2_decap_4
XFILLER_33_54 VDD VSS sg13g2_fill_2
XFILLER_33_76 VDD VSS sg13g2_decap_4
XFILLER_109_0 VDD VSS sg13g2_decap_8
XFILLER_106_573 VDD VSS sg13g2_decap_8
XFILLER_79_413 VDD VSS sg13g2_fill_2
XFILLER_3_188 VDD VSS sg13g2_decap_4
XFILLER_58_40 VDD VSS sg13g2_decap_8
XFILLER_67_608 VDD VSS sg13g2_fill_2
XFILLER_79_435 VDD VSS sg13g2_decap_8
XFILLER_0_851 VDD VSS sg13g2_decap_8
XFILLER_47_321 VDD VSS sg13g2_decap_8
XFILLER_48_822 VDD VSS sg13g2_decap_8
XFILLER_75_652 VDD VSS sg13g2_decap_8
XFILLER_47_387 VDD VSS sg13g2_decap_8
XFILLER_48_899 VDD VSS sg13g2_decap_8
XFILLER_62_324 VDD VSS sg13g2_decap_8
XFILLER_74_151 VDD VSS sg13g2_decap_8
XFILLER_74_184 VDD VSS sg13g2_decap_8
XFILLER_90_655 VDD VSS sg13g2_fill_1
XFILLER_15_262 VDD VSS sg13g2_decap_4
XFILLER_16_763 VDD VSS sg13g2_decap_8
X_2870_ _2870_/A0 _3105_/A0 _2873_/S _4305_/D VDD VSS sg13g2_mux2_1
XFILLER_30_243 VDD VSS sg13g2_decap_4
Xclkbuf_leaf_10_clk clkbuf_4_4_0_clk/X _4745_/CLK VDD VSS sg13g2_buf_8
X_4540_ fanout263/X VSS VDD _4540_/D _4540_/Q clkload5/A sg13g2_dfrbpq_1
X_4471_ fanout301/X VSS VDD _4471_/D _4471_/Q _4974_/CLK sg13g2_dfrbpq_1
X_4402__524 VDD VSS _4402_/RESET_B sg13g2_tiehi
XFILLER_116_359 VDD VSS sg13g2_decap_8
X_3422_ _3422_/A0 _3421_/Y _3422_/S _3422_/X VDD VSS sg13g2_mux2_1
X_3353_ _3353_/A _3353_/B _4635_/D VDD VSS sg13g2_nor2_1
XFILLER_98_755 VDD VSS sg13g2_fill_1
XFILLER_112_587 VDD VSS sg13g2_fill_2
XFILLER_24_0 VDD VSS sg13g2_decap_8
XFILLER_57_107 VDD VSS sg13g2_fill_1
XFILLER_58_608 VDD VSS sg13g2_decap_8
Xhold1106 _3151_/Y VDD VSS _4562_/D sg13g2_dlygate4sd3_1
X_3284_ VSS VDD hold772/X _3283_/Y _3284_/Y _3279_/A sg13g2_a21oi_1
X_2304_ VDD _2609_/B _3253_/A VSS sg13g2_inv_1
XFILLER_97_265 VDD VSS sg13g2_decap_8
XFILLER_38_310 VDD VSS sg13g2_decap_8
XFILLER_57_129 VDD VSS sg13g2_fill_1
Xhold1117 _4483_/Q VDD VSS _3544_/A1 sg13g2_dlygate4sd3_1
Xhold1128 _4478_/Q VDD VSS _3539_/A1 sg13g2_dlygate4sd3_1
Xhold1139 _4641_/Q VDD VSS _3648_/A1 sg13g2_dlygate4sd3_1
X_2235_ VDD _4871_/D _2540_/A VSS sg13g2_inv_1
XFILLER_66_652 VDD VSS sg13g2_decap_8
XFILLER_26_516 VDD VSS sg13g2_fill_2
XFILLER_53_313 VDD VSS sg13g2_decap_8
XFILLER_65_162 VDD VSS sg13g2_decap_8
XFILLER_65_173 VDD VSS sg13g2_fill_2
XFILLER_0_91 VDD VSS sg13g2_decap_8
XFILLER_81_677 VDD VSS sg13g2_decap_8
XFILLER_22_766 VDD VSS sg13g2_decap_8
X_4807_ fanout292/X VSS VDD _4807_/D _4807_/Q _4807_/CLK sg13g2_dfrbpq_1
XFILLER_21_287 VDD VSS sg13g2_decap_8
X_2999_ _2999_/A0 _3101_/A0 _3008_/S _4426_/D VDD VSS sg13g2_mux2_1
X_4738_ fanout273/X VSS VDD _4738_/D _4738_/Q _4942_/CLK sg13g2_dfrbpq_1
X_4669_ fanout251/X VSS VDD _4669_/D _4669_/Q clkload4/A sg13g2_dfrbpq_1
XFILLER_102_7 VDD VSS sg13g2_decap_8
Xhold940 _2908_/X VDD VSS _4340_/D sg13g2_dlygate4sd3_1
XFILLER_1_604 VDD VSS sg13g2_decap_8
Xhold951 _4282_/Q VDD VSS hold951/X sg13g2_dlygate4sd3_1
Xhold962 _2912_/X VDD VSS _4344_/D sg13g2_dlygate4sd3_1
Xhold973 _4415_/Q VDD VSS hold973/X sg13g2_dlygate4sd3_1
XFILLER_115_392 VDD VSS sg13g2_decap_8
Xhold984 _3238_/Y VDD VSS _4600_/D sg13g2_dlygate4sd3_1
Xhold995 _2945_/X VDD VSS _4375_/D sg13g2_dlygate4sd3_1
XFILLER_88_221 VDD VSS sg13g2_decap_8
XFILLER_0_147 VDD VSS sg13g2_decap_8
XFILLER_29_310 VDD VSS sg13g2_decap_8
XFILLER_48_129 VDD VSS sg13g2_decap_8
XFILLER_28_65 VDD VSS sg13g2_decap_8
XFILLER_56_140 VDD VSS sg13g2_decap_8
XFILLER_57_641 VDD VSS sg13g2_decap_8
Xhold1640 _3846_/Y VDD VSS _4789_/D sg13g2_dlygate4sd3_1
Xhold1651 _2618_/A VDD VSS _2619_/B sg13g2_dlygate4sd3_1
Xhold1662 _4724_/Q VDD VSS _3597_/A sg13g2_dlygate4sd3_1
XFILLER_91_408 VDD VSS sg13g2_decap_8
XFILLER_45_814 VDD VSS sg13g2_decap_8
XFILLER_45_836 VDD VSS sg13g2_fill_2
XFILLER_72_622 VDD VSS sg13g2_decap_8
XFILLER_84_471 VDD VSS sg13g2_decap_8
Xhold1673 _4649_/Q VDD VSS hold1673/X sg13g2_dlygate4sd3_1
XFILLER_56_195 VDD VSS sg13g2_decap_8
XFILLER_71_110 VDD VSS sg13g2_decap_8
XFILLER_13_711 VDD VSS sg13g2_decap_8
XFILLER_71_165 VDD VSS sg13g2_decap_8
XFILLER_13_722 VDD VSS sg13g2_fill_1
XFILLER_8_203 VDD VSS sg13g2_fill_1
XFILLER_9_748 VDD VSS sg13g2_decap_8
XFILLER_12_298 VDD VSS sg13g2_decap_8
XFILLER_5_921 VDD VSS sg13g2_decap_4
XFILLER_114_808 VDD VSS sg13g2_decap_8
XFILLER_5_14 VDD VSS sg13g2_decap_4
XFILLER_5_36 VDD VSS sg13g2_decap_8
XFILLER_107_860 VDD VSS sg13g2_decap_8
XFILLER_107_893 VDD VSS sg13g2_fill_2
XFILLER_4_464 VDD VSS sg13g2_decap_8
XFILLER_106_381 VDD VSS sg13g2_fill_2
XFILLER_79_265 VDD VSS sg13g2_fill_2
XFILLER_95_714 VDD VSS sg13g2_decap_8
Xclkbuf_leaf_59_clk clkbuf_4_2_0_clk/X clkload6/A VDD VSS sg13g2_buf_8
XFILLER_47_173 VDD VSS sg13g2_decap_4
XFILLER_75_482 VDD VSS sg13g2_decap_4
XFILLER_35_324 VDD VSS sg13g2_fill_1
XFILLER_35_335 VDD VSS sg13g2_fill_2
XFILLER_36_858 VDD VSS sg13g2_decap_8
XFILLER_51_817 VDD VSS sg13g2_fill_1
XFILLER_62_154 VDD VSS sg13g2_decap_8
X_3971_ _3972_/C VDD _3971_/Y VSS _4006_/B _4004_/A sg13g2_o21ai_1
XFILLER_90_474 VDD VSS sg13g2_fill_2
X_2922_ _2922_/A0 _3104_/A0 _2922_/S _4354_/D VDD VSS sg13g2_mux2_1
X_4326__400 VDD VSS _4326_/RESET_B sg13g2_tiehi
X_2853_ _2853_/A0 _3088_/A0 _2873_/S _4288_/D VDD VSS sg13g2_mux2_1
X_2784_ _2784_/A _2784_/B _4941_/D VDD VSS sg13g2_nor2_1
XFILLER_116_112 VDD VSS sg13g2_decap_8
X_4523_ fanout267/X VSS VDD _4523_/D _4523_/Q _4926_/CLK sg13g2_dfrbpq_1
XFILLER_7_291 VDD VSS sg13g2_decap_8
XFILLER_104_329 VDD VSS sg13g2_decap_4
X_4454_ _4454_/RESET_B VSS VDD _4454_/D _4454_/Q _4817_/CLK sg13g2_dfrbpq_1
X_4385_ _4385_/RESET_B VSS VDD _4385_/D _4385_/Q _4961_/CLK sg13g2_dfrbpq_1
X_3405_ _3405_/A _3405_/B _3405_/C _3405_/D _3406_/D VDD VSS sg13g2_or4_1
X_3336_ _3337_/A _3396_/A _3413_/D VDD VSS sg13g2_nor2_1
XFILLER_100_524 VDD VSS sg13g2_decap_8
XFILLER_105_37 VDD VSS sg13g2_fill_1
XFILLER_85_213 VDD VSS sg13g2_decap_4
XFILLER_85_246 VDD VSS sg13g2_decap_8
X_3267_ VSS VDD hold725/X _3266_/Y _3267_/Y _3289_/A sg13g2_a21oi_1
XFILLER_82_920 VDD VSS sg13g2_decap_4
X_3198_ _3232_/A _3200_/B _3198_/Y VDD VSS sg13g2_nor2_1
XFILLER_53_165 VDD VSS sg13g2_decap_8
XFILLER_54_688 VDD VSS sg13g2_decap_8
XFILLER_41_327 VDD VSS sg13g2_decap_8
XFILLER_53_187 VDD VSS sg13g2_decap_8
XFILLER_14_45 VDD VSS sg13g2_decap_4
XFILLER_22_552 VDD VSS sg13g2_decap_8
XFILLER_50_850 VDD VSS sg13g2_decap_8
XFILLER_10_758 VDD VSS sg13g2_decap_8
XFILLER_10_769 VDD VSS sg13g2_fill_2
XFILLER_6_707 VDD VSS sg13g2_decap_8
XFILLER_30_55 VDD VSS sg13g2_decap_8
XFILLER_107_167 VDD VSS sg13g2_decap_8
XFILLER_1_401 VDD VSS sg13g2_decap_8
Xhold781 _2584_/Y VDD VSS _4894_/D sg13g2_dlygate4sd3_1
Xhold770 _3810_/Y VDD VSS _4777_/D sg13g2_dlygate4sd3_1
XFILLER_103_340 VDD VSS sg13g2_decap_8
Xhold792 _4517_/Q VDD VSS hold792/X sg13g2_dlygate4sd3_1
XFILLER_103_373 VDD VSS sg13g2_decap_8
XFILLER_39_64 VDD VSS sg13g2_decap_8
XFILLER_49_438 VDD VSS sg13g2_decap_8
XFILLER_77_769 VDD VSS sg13g2_decap_8
XFILLER_92_717 VDD VSS sg13g2_fill_2
XFILLER_29_162 VDD VSS sg13g2_decap_8
XFILLER_73_920 VDD VSS sg13g2_decap_4
Xhold1470 _4576_/Q VDD VSS _3181_/A sg13g2_dlygate4sd3_1
XFILLER_18_869 VDD VSS sg13g2_decap_4
XFILLER_57_493 VDD VSS sg13g2_decap_8
Xhold1481 _4585_/Q VDD VSS _3202_/A sg13g2_dlygate4sd3_1
Xhold1492 _3168_/Y VDD VSS _4570_/D sg13g2_dlygate4sd3_1
XFILLER_17_368 VDD VSS sg13g2_fill_2
XFILLER_44_143 VDD VSS sg13g2_decap_8
XFILLER_45_677 VDD VSS sg13g2_decap_8
XFILLER_13_585 VDD VSS sg13g2_decap_8
XFILLER_71_62 VDD VSS sg13g2_fill_1
XFILLER_9_523 VDD VSS sg13g2_decap_8
XFILLER_9_578 VDD VSS sg13g2_decap_8
XFILLER_65_7 VDD VSS sg13g2_decap_8
XFILLER_113_104 VDD VSS sg13g2_decap_4
XFILLER_4_261 VDD VSS sg13g2_decap_8
XFILLER_5_795 VDD VSS sg13g2_decap_8
X_4170_ _4170_/Y _4170_/B _4169_/A VDD VSS sg13g2_nand2b_1
XFILLER_67_213 VDD VSS sg13g2_decap_8
X_3121_ _4626_/Q _3121_/A1 _3128_/B _3121_/X VDD VSS sg13g2_mux2_1
XFILLER_96_92 VDD VSS sg13g2_fill_1
XFILLER_36_600 VDD VSS sg13g2_decap_8
XFILLER_64_920 VDD VSS sg13g2_decap_4
XFILLER_67_279 VDD VSS sg13g2_decap_8
XFILLER_76_780 VDD VSS sg13g2_decap_8
X_3052_ _3539_/A1 _4503_/Q _3058_/S _3052_/X VDD VSS sg13g2_mux2_1
XFILLER_35_121 VDD VSS sg13g2_decap_4
XFILLER_36_655 VDD VSS sg13g2_decap_8
XFILLER_63_430 VDD VSS sg13g2_decap_8
XFILLER_82_238 VDD VSS sg13g2_fill_1
XFILLER_91_750 VDD VSS sg13g2_decap_8
XFILLER_23_316 VDD VSS sg13g2_decap_8
XFILLER_50_124 VDD VSS sg13g2_decap_8
XFILLER_51_647 VDD VSS sg13g2_decap_8
XFILLER_63_496 VDD VSS sg13g2_decap_8
XFILLER_90_293 VDD VSS sg13g2_decap_8
XFILLER_23_349 VDD VSS sg13g2_decap_8
X_3954_ _3954_/A _3954_/B _3954_/C _3954_/D _3959_/B VDD VSS sg13g2_nor4_1
XFILLER_91_0 VDD VSS sg13g2_decap_8
X_3885_ VSS VDD _3905_/C _3882_/Y _3887_/A _2242_/Y sg13g2_a21oi_1
X_2905_ _2905_/A0 _3087_/A0 _2928_/S _4337_/D VDD VSS sg13g2_mux2_1
X_2836_ _2836_/A0 _3098_/A0 _2847_/S _4273_/D VDD VSS sg13g2_mux2_1
X_2767_ _2784_/A _2767_/B _2771_/C _2767_/Y VDD VSS sg13g2_nor3_1
X_4506_ fanout298/X VSS VDD _4506_/D _4506_/Q _4976_/CLK sg13g2_dfrbpq_1
X_2698_ _2698_/Y _4860_/Q _2698_/B VDD VSS sg13g2_nand2_1
XFILLER_105_649 VDD VSS sg13g2_decap_8
XFILLER_116_14 VDD VSS sg13g2_decap_8
X_4437_ _4437_/RESET_B VSS VDD _4437_/D _4437_/Q clkload8/A sg13g2_dfrbpq_1
XFILLER_58_213 VDD VSS sg13g2_decap_8
XFILLER_76_18 VDD VSS sg13g2_fill_2
X_4368_ _4368_/RESET_B VSS VDD _4368_/D _4368_/Q clkload6/A sg13g2_dfrbpq_1
XFILLER_101_844 VDD VSS sg13g2_decap_8
XFILLER_74_706 VDD VSS sg13g2_decap_8
X_4299_ _4299_/RESET_B VSS VDD _4299_/D _4299_/Q _4968_/CLK sg13g2_dfrbpq_1
X_3319_ _3319_/B _3396_/C _4782_/Q _3319_/Y VDD VSS _3319_/D sg13g2_nand4_1
XFILLER_86_566 VDD VSS sg13g2_decap_8
XFILLER_100_376 VDD VSS sg13g2_decap_8
XFILLER_101_899 VDD VSS sg13g2_decap_8
XFILLER_39_471 VDD VSS sg13g2_decap_8
XFILLER_73_205 VDD VSS sg13g2_decap_8
XFILLER_15_817 VDD VSS sg13g2_decap_8
XFILLER_26_154 VDD VSS sg13g2_decap_8
XFILLER_41_102 VDD VSS sg13g2_decap_8
XFILLER_54_474 VDD VSS sg13g2_decap_8
XFILLER_23_861 VDD VSS sg13g2_decap_8
XFILLER_50_680 VDD VSS sg13g2_decap_8
XFILLER_10_533 VDD VSS sg13g2_decap_8
XFILLER_22_393 VDD VSS sg13g2_decap_8
XFILLER_108_410 VDD VSS sg13g2_decap_8
XFILLER_41_76 VDD VSS sg13g2_fill_2
XFILLER_6_559 VDD VSS sg13g2_decap_8
XFILLER_108_498 VDD VSS sg13g2_decap_8
XFILLER_2_743 VDD VSS sg13g2_decap_8
XFILLER_96_308 VDD VSS sg13g2_decap_8
XFILLER_104_682 VDD VSS sg13g2_decap_8
XFILLER_1_253 VDD VSS sg13g2_decap_8
XFILLER_49_213 VDD VSS sg13g2_decap_8
XFILLER_49_224 VDD VSS sg13g2_fill_1
X_4316__410 VDD VSS _4316_/RESET_B sg13g2_tiehi
XFILLER_49_268 VDD VSS sg13g2_decap_8
XFILLER_65_717 VDD VSS sg13g2_decap_8
XFILLER_77_588 VDD VSS sg13g2_decap_8
XFILLER_18_633 VDD VSS sg13g2_decap_8
XFILLER_66_84 VDD VSS sg13g2_decap_8
XFILLER_80_709 VDD VSS sg13g2_decap_8
XFILLER_32_113 VDD VSS sg13g2_decap_8
XFILLER_45_496 VDD VSS sg13g2_decap_8
XFILLER_82_61 VDD VSS sg13g2_decap_8
XFILLER_14_872 VDD VSS sg13g2_decap_8
XFILLER_32_168 VDD VSS sg13g2_decap_8
XFILLER_60_488 VDD VSS sg13g2_decap_8
XFILLER_13_393 VDD VSS sg13g2_decap_4
X_4323__403 VDD VSS _4323_/RESET_B sg13g2_tiehi
X_3670_ VSS VDD _4734_/Q _3667_/B _3670_/Y _3718_/B sg13g2_a21oi_1
XFILLER_9_364 VDD VSS sg13g2_decap_8
X_2621_ VDD _5180_/A _2621_/A VSS sg13g2_inv_1
X_2552_ _2552_/A _2552_/B _2552_/C _2556_/C VDD VSS sg13g2_nor3_1
X_4222_ _4222_/A _4432_/Q _4222_/Y VDD VSS sg13g2_nor2_1
X_2483_ _2483_/A _3935_/A _3928_/A _3935_/C _2485_/C VDD VSS sg13g2_nor4_1
XFILLER_99_168 VDD VSS sg13g2_decap_8
XFILLER_68_500 VDD VSS sg13g2_fill_2
XFILLER_56_706 VDD VSS sg13g2_decap_8
XFILLER_68_566 VDD VSS sg13g2_fill_1
X_4153_ _4236_/A1 VDD _4153_/Y VSS _4151_/Y _4152_/Y sg13g2_o21ai_1
XFILLER_96_842 VDD VSS sg13g2_fill_2
XFILLER_95_341 VDD VSS sg13g2_fill_1
X_4084_ _4368_/Q _4393_/Q _4144_/S _4084_/X VDD VSS sg13g2_mux2_1
X_3104_ _3104_/A0 _3130_/A _3104_/S _4528_/D VDD VSS sg13g2_mux2_1
XFILLER_95_374 VDD VSS sg13g2_decap_8
XFILLER_55_227 VDD VSS sg13g2_decap_8
X_3035_ hold774/X hold889/X _3057_/S _4461_/D VDD VSS sg13g2_mux2_1
XFILLER_102_49 VDD VSS sg13g2_decap_8
XFILLER_36_485 VDD VSS sg13g2_decap_4
XFILLER_23_157 VDD VSS sg13g2_fill_2
XFILLER_23_168 VDD VSS sg13g2_fill_2
X_3937_ VDD _3937_/Y _3944_/C VSS sg13g2_inv_1
XFILLER_20_842 VDD VSS sg13g2_decap_8
XFILLER_32_691 VDD VSS sg13g2_decap_8
XFILLER_20_886 VDD VSS sg13g2_fill_1
X_3868_ _3929_/A _3868_/A _3868_/B VDD VSS sg13g2_nand2_1
X_3799_ _3832_/A _3832_/B _3835_/B VDD VSS sg13g2_nor2_1
X_2819_ _2819_/A _2819_/B _4926_/D VDD VSS sg13g2_and2_1
XFILLER_106_925 VDD VSS sg13g2_fill_1
XFILLER_11_35 VDD VSS sg13g2_fill_1
XFILLER_105_413 VDD VSS sg13g2_decap_8
XFILLER_105_446 VDD VSS sg13g2_fill_1
Xfanout310 fanout311/X fanout310/X VDD VSS sg13g2_buf_1
Xfanout321 fanout324/X fanout321/X VDD VSS sg13g2_buf_1
Xfanout332 fanout335/X fanout332/X VDD VSS sg13g2_buf_1
XFILLER_87_842 VDD VSS sg13g2_decap_8
XFILLER_100_151 VDD VSS sg13g2_decap_8
XFILLER_101_652 VDD VSS sg13g2_fill_1
XFILLER_19_419 VDD VSS sg13g2_decap_8
XFILLER_59_566 VDD VSS sg13g2_decap_4
XFILLER_36_21 VDD VSS sg13g2_decap_4
XFILLER_46_227 VDD VSS sg13g2_decap_8
XFILLER_74_536 VDD VSS sg13g2_fill_1
XFILLER_15_614 VDD VSS sg13g2_fill_1
XFILLER_27_496 VDD VSS sg13g2_decap_4
XFILLER_42_411 VDD VSS sg13g2_fill_1
XFILLER_54_260 VDD VSS sg13g2_fill_2
XFILLER_54_271 VDD VSS sg13g2_decap_8
XFILLER_15_647 VDD VSS sg13g2_decap_8
XFILLER_42_444 VDD VSS sg13g2_decap_8
XFILLER_42_455 VDD VSS sg13g2_fill_2
XFILLER_14_168 VDD VSS sg13g2_decap_8
XFILLER_52_42 VDD VSS sg13g2_decap_8
XFILLER_108_251 VDD VSS sg13g2_decap_8
XFILLER_109_763 VDD VSS sg13g2_fill_2
XFILLER_7_879 VDD VSS sg13g2_decap_8
XFILLER_111_416 VDD VSS sg13g2_decap_8
XFILLER_97_639 VDD VSS sg13g2_fill_1
XFILLER_28_7 VDD VSS sg13g2_fill_2
XFILLER_77_72 VDD VSS sg13g2_fill_2
XFILLER_96_138 VDD VSS sg13g2_decap_4
XFILLER_89_190 VDD VSS sg13g2_decap_8
XFILLER_38_706 VDD VSS sg13g2_decap_8
XFILLER_65_514 VDD VSS sg13g2_decap_8
XFILLER_77_352 VDD VSS sg13g2_decap_8
XFILLER_77_94 VDD VSS sg13g2_fill_1
XFILLER_93_801 VDD VSS sg13g2_decap_8
XFILLER_77_396 VDD VSS sg13g2_fill_1
XFILLER_93_878 VDD VSS sg13g2_fill_1
XFILLER_93_60 VDD VSS sg13g2_decap_8
XFILLER_34_912 VDD VSS sg13g2_decap_8
XFILLER_46_794 VDD VSS sg13g2_decap_8
X_4840_ fanout275/X VSS VDD _4840_/D _4840_/Q _4954_/CLK sg13g2_dfrbpq_1
XFILLER_21_628 VDD VSS sg13g2_decap_8
XFILLER_33_488 VDD VSS sg13g2_decap_8
XFILLER_61_786 VDD VSS sg13g2_decap_8
XFILLER_60_296 VDD VSS sg13g2_decap_8
X_4771_ fanout248/X VSS VDD _4771_/D _4771_/Q clkload1/A sg13g2_dfrbpq_1
X_3722_ _3722_/Y _3722_/A _3722_/B VDD VSS sg13g2_nand2_1
X_3653_ _3653_/A0 _4645_/Q _3653_/S _3653_/X VDD VSS sg13g2_mux2_1
X_2604_ VDD _2604_/Y _2604_/A VSS sg13g2_inv_1
XFILLER_115_733 VDD VSS sg13g2_decap_8
XFILLER_54_0 VDD VSS sg13g2_decap_8
X_3584_ _3585_/B _3584_/A _3584_/B VDD VSS sg13g2_xnor2_1
X_2535_ _3528_/A _3294_/A _4933_/D VDD VSS sg13g2_and2_1
XFILLER_102_416 VDD VSS sg13g2_decap_8
X_2466_ _2466_/A _3051_/S _4851_/D VDD VSS sg13g2_nor2b_1
X_4205_ _2347_/A VDD _4205_/Y VSS _4205_/A1 _4455_/Q sg13g2_o21ai_1
XFILLER_28_205 VDD VSS sg13g2_fill_1
XFILLER_56_503 VDD VSS sg13g2_decap_8
XFILLER_68_374 VDD VSS sg13g2_decap_8
XFILLER_84_801 VDD VSS sg13g2_decap_8
X_4136_ VSS VDD _4225_/A1 _4132_/X _4136_/Y _4135_/Y sg13g2_a21oi_1
X_2397_ VSS VDD _2395_/A _2395_/B _2397_/Y _2396_/X sg13g2_a21oi_1
XFILLER_110_482 VDD VSS sg13g2_decap_8
XFILLER_28_227 VDD VSS sg13g2_fill_2
X_4067_ _4066_/Y VDD _4067_/Y VSS _4064_/Y _4065_/Y sg13g2_o21ai_1
X_3018_ hold902/X _4518_/Q _3034_/S _3018_/X VDD VSS sg13g2_mux2_1
XFILLER_24_455 VDD VSS sg13g2_decap_8
XFILLER_51_274 VDD VSS sg13g2_decap_4
X_4969_ fanout301/X VSS VDD _4969_/D _4969_/Q _4977_/CLK sg13g2_dfrbpq_1
XFILLER_20_683 VDD VSS sg13g2_decap_8
XFILLER_22_67 VDD VSS sg13g2_decap_8
X_4306__420 VDD VSS _4306_/RESET_B sg13g2_tiehi
XFILLER_4_816 VDD VSS sg13g2_decap_8
XFILLER_106_755 VDD VSS sg13g2_decap_8
XFILLER_106_766 VDD VSS sg13g2_fill_2
XFILLER_105_298 VDD VSS sg13g2_decap_8
Xfanout140 _4188_/A1 _4250_/A1 VDD VSS sg13g2_buf_1
Xfanout151 hold1311/X _3110_/S VDD VSS sg13g2_buf_1
Xfanout162 fanout165/X _4169_/A VDD VSS sg13g2_buf_1
Xfanout173 _4243_/B1 _4245_/A1 VDD VSS sg13g2_buf_1
XFILLER_101_493 VDD VSS sg13g2_decap_8
XFILLER_47_64 VDD VSS sg13g2_decap_8
XFILLER_59_396 VDD VSS sg13g2_decap_8
Xfanout184 fanout188/X _4226_/S1 VDD VSS sg13g2_buf_1
Xfanout195 _4825_/Q _4242_/S VDD VSS sg13g2_buf_1
XFILLER_86_182 VDD VSS sg13g2_decap_8
XFILLER_28_761 VDD VSS sg13g2_fill_1
X_4313__413 VDD VSS _4313_/RESET_B sg13g2_tiehi
XFILLER_27_260 VDD VSS sg13g2_decap_8
XFILLER_28_772 VDD VSS sg13g2_decap_8
XFILLER_15_422 VDD VSS sg13g2_decap_8
XFILLER_43_742 VDD VSS sg13g2_decap_8
XFILLER_90_859 VDD VSS sg13g2_decap_8
XFILLER_63_63 VDD VSS sg13g2_fill_1
XFILLER_30_447 VDD VSS sg13g2_decap_8
XFILLER_11_672 VDD VSS sg13g2_decap_8
XFILLER_10_171 VDD VSS sg13g2_decap_8
XFILLER_116_519 VDD VSS sg13g2_decap_8
XFILLER_6_120 VDD VSS sg13g2_decap_8
XFILLER_7_654 VDD VSS sg13g2_decap_8
X_4320__406 VDD VSS _4320_/RESET_B sg13g2_tiehi
XFILLER_109_571 VDD VSS sg13g2_decap_8
XFILLER_109_582 VDD VSS sg13g2_fill_2
XFILLER_109_593 VDD VSS sg13g2_decap_4
XFILLER_6_164 VDD VSS sg13g2_decap_8
XFILLER_69_116 VDD VSS sg13g2_decap_8
X_2320_ VDD _3419_/C _4791_/Q VSS sg13g2_inv_1
XFILLER_111_224 VDD VSS sg13g2_decap_4
X_2251_ VDD _3954_/B _2251_/A VSS sg13g2_inv_1
XFILLER_97_469 VDD VSS sg13g2_decap_8
XFILLER_38_525 VDD VSS sg13g2_decap_8
XFILLER_38_547 VDD VSS sg13g2_decap_8
XFILLER_66_845 VDD VSS sg13g2_decap_4
XFILLER_81_815 VDD VSS sg13g2_decap_8
Xclkbuf_4_1_0_clk clkbuf_0_clk/X clkbuf_4_1_0_clk/X VDD VSS sg13g2_buf_8
XFILLER_93_664 VDD VSS sg13g2_fill_1
XFILLER_81_826 VDD VSS sg13g2_fill_2
XFILLER_92_152 VDD VSS sg13g2_decap_8
XFILLER_22_915 VDD VSS sg13g2_decap_8
XFILLER_34_797 VDD VSS sg13g2_fill_2
X_4823_ fanout314/X VSS VDD _4823_/D _4823_/Q _4824_/CLK sg13g2_dfrbpq_1
XFILLER_21_469 VDD VSS sg13g2_decap_8
X_4754_ fanout268/X VSS VDD _4754_/D _4754_/Q _4841_/CLK sg13g2_dfrbpq_1
X_3705_ _3705_/Y _4733_/Q _3705_/B VDD VSS sg13g2_nand2_1
X_4685_ fanout310/X VSS VDD _4685_/D _4685_/Q _4869_/CLK sg13g2_dfrbpq_1
X_3636_ _3636_/A _3636_/B _3636_/C _3698_/C _3636_/Y VDD VSS sg13g2_nor4_1
XFILLER_115_530 VDD VSS sg13g2_decap_8
X_3567_ VSS VDD _3563_/A _4716_/Q _3568_/C _3569_/A1 sg13g2_a21oi_1
X_2518_ _4845_/Q _4690_/Q _4847_/D _4121_/A _2520_/A VDD VSS sg13g2_nor4_1
XFILLER_102_213 VDD VSS sg13g2_fill_1
X_3498_ _3529_/B _3556_/A _3498_/B VDD VSS sg13g2_nand2_1
XFILLER_102_257 VDD VSS sg13g2_decap_4
X_2449_ _4004_/A _2450_/B _3640_/B VDD VSS sg13g2_nor2b_1
XFILLER_56_322 VDD VSS sg13g2_fill_2
XFILLER_68_160 VDD VSS sg13g2_decap_8
XFILLER_84_631 VDD VSS sg13g2_decap_8
XFILLER_96_480 VDD VSS sg13g2_decap_8
XFILLER_110_290 VDD VSS sg13g2_decap_8
XFILLER_29_558 VDD VSS sg13g2_fill_1
X_4119_ VSS VDD _4199_/A1 _4118_/X _4119_/Y _2348_/A sg13g2_a21oi_1
XFILLER_72_826 VDD VSS sg13g2_decap_8
XFILLER_83_163 VDD VSS sg13g2_decap_8
XFILLER_25_720 VDD VSS sg13g2_fill_1
XFILLER_71_358 VDD VSS sg13g2_decap_8
XFILLER_83_196 VDD VSS sg13g2_decap_8
XFILLER_24_252 VDD VSS sg13g2_fill_1
XFILLER_12_414 VDD VSS sg13g2_decap_8
XFILLER_52_583 VDD VSS sg13g2_fill_1
XFILLER_9_919 VDD VSS sg13g2_decap_8
XFILLER_106_552 VDD VSS sg13g2_decap_8
XFILLER_3_167 VDD VSS sg13g2_decap_8
XFILLER_0_830 VDD VSS sg13g2_decap_8
XFILLER_48_801 VDD VSS sg13g2_decap_8
XFILLER_47_300 VDD VSS sg13g2_decap_8
XFILLER_58_96 VDD VSS sg13g2_decap_8
XFILLER_94_428 VDD VSS sg13g2_decap_8
XFILLER_87_491 VDD VSS sg13g2_decap_4
XFILLER_48_878 VDD VSS sg13g2_decap_8
XFILLER_74_130 VDD VSS sg13g2_decap_8
XFILLER_62_303 VDD VSS sg13g2_decap_8
XFILLER_74_40 VDD VSS sg13g2_decap_8
XFILLER_75_686 VDD VSS sg13g2_fill_1
XFILLER_90_612 VDD VSS sg13g2_decap_8
XFILLER_16_742 VDD VSS sg13g2_decap_8
XFILLER_90_689 VDD VSS sg13g2_decap_4
XFILLER_15_285 VDD VSS sg13g2_decap_8
XFILLER_30_222 VDD VSS sg13g2_decap_8
XFILLER_95_7 VDD VSS sg13g2_decap_8
XFILLER_90_50 VDD VSS sg13g2_fill_1
XFILLER_30_288 VDD VSS sg13g2_decap_8
XFILLER_116_338 VDD VSS sg13g2_decap_4
X_4470_ fanout323/X VSS VDD _4470_/D _4470_/Q _4972_/CLK sg13g2_dfrbpq_1
XFILLER_7_495 VDD VSS sg13g2_decap_8
X_3421_ _3425_/B _3421_/C _3421_/A _3421_/Y VDD VSS sg13g2_nand3_1
X_3352_ _3408_/A VDD _3353_/B VSS _3357_/B _3350_/C sg13g2_o21ai_1
X_2303_ VDD _2609_/A _3251_/A VSS sg13g2_inv_1
XFILLER_86_907 VDD VSS sg13g2_decap_8
X_3283_ _4006_/A _3286_/B _3283_/Y VDD VSS sg13g2_nor2_1
XFILLER_97_244 VDD VSS sg13g2_decap_8
XFILLER_66_631 VDD VSS sg13g2_decap_8
Xhold1107 _4338_/Q VDD VSS _2906_/A0 sg13g2_dlygate4sd3_1
Xhold1118 _3544_/X VDD VSS _4706_/D sg13g2_dlygate4sd3_1
Xhold1129 _3052_/X VDD VSS _4478_/D sg13g2_dlygate4sd3_1
X_2234_ VDD _2234_/Y _2234_/A VSS sg13g2_inv_1
XFILLER_17_0 VDD VSS sg13g2_decap_8
XFILLER_54_826 VDD VSS sg13g2_decap_4
XFILLER_0_70 VDD VSS sg13g2_decap_8
XFILLER_19_591 VDD VSS sg13g2_decap_4
XFILLER_54_859 VDD VSS sg13g2_decap_8
XFILLER_80_133 VDD VSS sg13g2_decap_8
XFILLER_110_49 VDD VSS sg13g2_decap_8
XFILLER_21_200 VDD VSS sg13g2_fill_1
XFILLER_22_745 VDD VSS sg13g2_decap_8
XFILLER_80_199 VDD VSS sg13g2_fill_2
XFILLER_21_233 VDD VSS sg13g2_decap_8
X_4806_ fanout292/X VSS VDD _4806_/D _4806_/Q _4807_/CLK sg13g2_dfrbpq_1
X_2998_ hold990/X _3100_/A0 _3003_/S _2998_/X VDD VSS sg13g2_mux2_1
X_4737_ fanout284/X VSS VDD _4737_/D _4737_/Q _4737_/CLK sg13g2_dfrbpq_1
X_4668_ fanout268/X VSS VDD _4668_/D _4668_/Q _4745_/CLK sg13g2_dfrbpq_1
X_4303__423 VDD VSS _4303_/RESET_B sg13g2_tiehi
Xhold930 _4267_/Q VDD VSS hold930/X sg13g2_dlygate4sd3_1
X_3619_ _3619_/A0 _4626_/Q _3654_/S _3619_/X VDD VSS sg13g2_mux2_1
Xhold941 _4796_/Q VDD VSS hold941/X sg13g2_dlygate4sd3_1
Xhold952 _4289_/Q VDD VSS hold952/X sg13g2_dlygate4sd3_1
Xhold963 _4382_/Q VDD VSS hold963/X sg13g2_dlygate4sd3_1
X_4599_ fanout288/X VSS VDD _4599_/D _4599_/Q _4601_/CLK sg13g2_dfrbpq_1
XFILLER_88_200 VDD VSS sg13g2_decap_8
XFILLER_0_126 VDD VSS sg13g2_decap_8
XFILLER_115_371 VDD VSS sg13g2_decap_8
XFILLER_116_894 VDD VSS sg13g2_decap_8
XFILLER_77_907 VDD VSS sg13g2_decap_8
Xhold974 _2988_/X VDD VSS _4415_/D sg13g2_dlygate4sd3_1
Xhold985 _4384_/Q VDD VSS hold985/X sg13g2_dlygate4sd3_1
Xhold996 _4795_/Q VDD VSS hold996/X sg13g2_dlygate4sd3_1
XFILLER_89_756 VDD VSS sg13g2_decap_8
XFILLER_49_609 VDD VSS sg13g2_fill_2
XFILLER_95_28 VDD VSS sg13g2_decap_8
XFILLER_57_620 VDD VSS sg13g2_decap_8
XFILLER_88_277 VDD VSS sg13g2_decap_8
XFILLER_28_44 VDD VSS sg13g2_decap_8
Xhold1630 _4863_/Q VDD VSS _2704_/B sg13g2_dlygate4sd3_1
Xhold1641 _4740_/Q VDD VSS hold1641/X sg13g2_dlygate4sd3_1
Xhold1652 _4623_/Q VDD VSS hold1652/X sg13g2_dlygate4sd3_1
XFILLER_29_366 VDD VSS sg13g2_decap_8
XFILLER_29_377 VDD VSS sg13g2_fill_2
XFILLER_57_697 VDD VSS sg13g2_decap_8
XFILLER_72_601 VDD VSS sg13g2_decap_8
Xhold1663 _4860_/Q VDD VSS _3501_/A1 sg13g2_dlygate4sd3_1
Xhold1674 _4765_/Q VDD VSS _3764_/C sg13g2_dlygate4sd3_1
XFILLER_29_399 VDD VSS sg13g2_decap_8
XFILLER_45_859 VDD VSS sg13g2_decap_8
XFILLER_56_185 VDD VSS sg13g2_fill_1
X_4310__416 VDD VSS _4310_/RESET_B sg13g2_tiehi
XFILLER_25_550 VDD VSS sg13g2_decap_4
XFILLER_44_21 VDD VSS sg13g2_decap_4
XFILLER_72_678 VDD VSS sg13g2_decap_4
XFILLER_12_200 VDD VSS sg13g2_fill_2
XFILLER_12_233 VDD VSS sg13g2_decap_8
XFILLER_12_244 VDD VSS sg13g2_fill_1
XFILLER_100_60 VDD VSS sg13g2_decap_8
XFILLER_100_82 VDD VSS sg13g2_decap_8
XFILLER_13_789 VDD VSS sg13g2_decap_8
XFILLER_8_237 VDD VSS sg13g2_decap_8
XFILLER_60_42 VDD VSS sg13g2_decap_8
XFILLER_5_900 VDD VSS sg13g2_decap_8
XFILLER_99_509 VDD VSS sg13g2_decap_8
XFILLER_4_454 VDD VSS sg13g2_fill_1
XFILLER_69_62 VDD VSS sg13g2_decap_8
XFILLER_68_918 VDD VSS sg13g2_decap_4
XFILLER_79_244 VDD VSS sg13g2_decap_8
XFILLER_79_277 VDD VSS sg13g2_decap_4
XFILLER_79_299 VDD VSS sg13g2_decap_8
XFILLER_10_7 VDD VSS sg13g2_decap_8
XFILLER_35_303 VDD VSS sg13g2_fill_1
XFILLER_36_837 VDD VSS sg13g2_decap_8
XFILLER_63_601 VDD VSS sg13g2_decap_8
XFILLER_63_656 VDD VSS sg13g2_decap_8
XFILLER_90_431 VDD VSS sg13g2_decap_8
X_3970_ VSS VDD _2634_/B _3976_/B _4828_/D _3969_/Y sg13g2_a21oi_1
XFILLER_16_572 VDD VSS sg13g2_fill_2
XFILLER_50_328 VDD VSS sg13g2_decap_8
X_2921_ hold928/X _3103_/A0 _2922_/S _2921_/X VDD VSS sg13g2_mux2_1
XFILLER_31_564 VDD VSS sg13g2_decap_8
XFILLER_31_575 VDD VSS sg13g2_fill_1
X_2852_ _2852_/A0 _3087_/A0 _2875_/S _4287_/D VDD VSS sg13g2_mux2_1
X_2783_ _2783_/B _2783_/A _2783_/X VDD VSS sg13g2_xor2_1
X_4522_ fanout299/X VSS VDD _4522_/D _4522_/Q _4976_/CLK sg13g2_dfrbpq_1
XFILLER_8_771 VDD VSS sg13g2_decap_8
X_4453_ _4453_/RESET_B VSS VDD _4453_/D _4453_/Q _4972_/CLK sg13g2_dfrbpq_1
XFILLER_104_308 VDD VSS sg13g2_decap_8
XFILLER_116_179 VDD VSS sg13g2_decap_8
X_3404_ _3339_/B VDD _3406_/C VSS _3402_/Y _3403_/Y sg13g2_o21ai_1
X_4384_ _4384_/RESET_B VSS VDD _4384_/D _4384_/Q _4967_/CLK sg13g2_dfrbpq_1
X_3335_ _3396_/B VDD _3335_/Y VSS _3398_/C _3334_/Y sg13g2_o21ai_1
XFILLER_98_564 VDD VSS sg13g2_fill_2
XFILLER_98_553 VDD VSS sg13g2_decap_8
XFILLER_100_503 VDD VSS sg13g2_decap_8
XFILLER_58_417 VDD VSS sg13g2_fill_2
X_3266_ VSS VDD _2615_/A _2615_/C _3266_/Y _4006_/A sg13g2_a21oi_1
XFILLER_27_826 VDD VSS sg13g2_fill_1
X_3197_ _2589_/C VDD _3197_/Y VSS _4581_/Q _4582_/Q sg13g2_o21ai_1
XFILLER_54_634 VDD VSS sg13g2_decap_8
XFILLER_66_494 VDD VSS sg13g2_decap_8
XFILLER_81_431 VDD VSS sg13g2_decap_8
XFILLER_14_509 VDD VSS sg13g2_decap_8
XFILLER_53_133 VDD VSS sg13g2_fill_1
XFILLER_53_144 VDD VSS sg13g2_decap_8
XFILLER_81_442 VDD VSS sg13g2_fill_2
XFILLER_22_520 VDD VSS sg13g2_fill_1
XFILLER_22_531 VDD VSS sg13g2_decap_8
XFILLER_10_704 VDD VSS sg13g2_decap_8
XFILLER_108_625 VDD VSS sg13g2_decap_8
XFILLER_5_207 VDD VSS sg13g2_decap_8
XFILLER_107_146 VDD VSS sg13g2_decap_8
XFILLER_2_925 VDD VSS sg13g2_fill_1
XFILLER_116_691 VDD VSS sg13g2_decap_8
Xhold782 _4966_/Q VDD VSS _4130_/B sg13g2_dlygate4sd3_1
Xhold771 _4619_/Q VDD VSS _2617_/B sg13g2_dlygate4sd3_1
Xhold760 _4567_/Q VDD VSS _3160_/B sg13g2_dlygate4sd3_1
XFILLER_103_352 VDD VSS sg13g2_decap_8
XFILLER_104_853 VDD VSS sg13g2_decap_4
XFILLER_115_190 VDD VSS sg13g2_decap_8
XFILLER_77_715 VDD VSS sg13g2_fill_2
Xhold793 _3093_/X VDD VSS _4517_/D sg13g2_dlygate4sd3_1
XFILLER_89_553 VDD VSS sg13g2_decap_4
XFILLER_1_479 VDD VSS sg13g2_decap_8
XFILLER_39_43 VDD VSS sg13g2_decap_8
XFILLER_49_417 VDD VSS sg13g2_decap_8
XFILLER_29_130 VDD VSS sg13g2_fill_1
XFILLER_76_236 VDD VSS sg13g2_fill_2
XFILLER_18_804 VDD VSS sg13g2_decap_8
XFILLER_45_601 VDD VSS sg13g2_fill_2
Xhold1460 _4951_/Q VDD VSS _2745_/A sg13g2_dlygate4sd3_1
XFILLER_92_729 VDD VSS sg13g2_fill_2
XFILLER_18_848 VDD VSS sg13g2_decap_8
XFILLER_57_483 VDD VSS sg13g2_decap_4
Xhold1471 _3181_/X VDD VSS _3182_/B sg13g2_dlygate4sd3_1
Xhold1482 _3202_/Y VDD VSS _3203_/A2 sg13g2_dlygate4sd3_1
Xhold1493 _4606_/Q VDD VSS _3251_/A sg13g2_dlygate4sd3_1
XFILLER_55_86 VDD VSS sg13g2_decap_8
XFILLER_60_604 VDD VSS sg13g2_fill_1
XFILLER_72_453 VDD VSS sg13g2_decap_8
XFILLER_55_97 VDD VSS sg13g2_fill_2
XFILLER_111_70 VDD VSS sg13g2_fill_2
XFILLER_111_92 VDD VSS sg13g2_decap_8
XFILLER_13_531 VDD VSS sg13g2_fill_1
XFILLER_13_564 VDD VSS sg13g2_decap_8
XFILLER_41_873 VDD VSS sg13g2_decap_8
XFILLER_40_383 VDD VSS sg13g2_decap_8
XFILLER_114_606 VDD VSS sg13g2_fill_1
XFILLER_4_240 VDD VSS sg13g2_decap_8
XFILLER_58_7 VDD VSS sg13g2_decap_8
XFILLER_5_774 VDD VSS sg13g2_decap_8
XFILLER_99_317 VDD VSS sg13g2_decap_8
XFILLER_110_812 VDD VSS sg13g2_decap_4
XFILLER_68_737 VDD VSS sg13g2_decap_8
X_3120_ _4625_/Q hold946/X _3128_/B _3120_/X VDD VSS sg13g2_mux2_1
XFILLER_110_856 VDD VSS sg13g2_fill_1
X_3051_ _3538_/A1 hold908/X _3051_/S _4477_/D VDD VSS sg13g2_mux2_1
XFILLER_35_100 VDD VSS sg13g2_decap_8
XFILLER_36_634 VDD VSS sg13g2_decap_8
XFILLER_24_807 VDD VSS sg13g2_decap_8
XFILLER_91_773 VDD VSS sg13g2_fill_1
XFILLER_23_328 VDD VSS sg13g2_decap_8
XFILLER_35_177 VDD VSS sg13g2_decap_8
XFILLER_35_188 VDD VSS sg13g2_fill_2
XFILLER_50_103 VDD VSS sg13g2_decap_8
XFILLER_51_626 VDD VSS sg13g2_decap_8
XFILLER_35_199 VDD VSS sg13g2_fill_2
X_3953_ _3953_/A _3953_/B _3956_/A VDD VSS sg13g2_and2_1
XFILLER_50_169 VDD VSS sg13g2_decap_8
X_3884_ VSS VDD _3905_/C _3882_/Y _4804_/D hold768/X sg13g2_a21oi_1
X_2904_ _2904_/A0 _3086_/A0 _2928_/S _4336_/D VDD VSS sg13g2_mux2_1
XFILLER_84_0 VDD VSS sg13g2_decap_8
X_2835_ _2835_/A0 _3021_/A1 _2846_/S _2835_/X VDD VSS sg13g2_mux2_1
X_2766_ _2766_/A _2766_/B _2771_/C VDD VSS sg13g2_and2_1
XFILLER_105_628 VDD VSS sg13g2_decap_8
X_4505_ fanout306/X VSS VDD _4505_/D _4505_/Q _4975_/CLK sg13g2_dfrbpq_1
X_2697_ _2697_/Y _3522_/A _2499_/B VDD VSS sg13g2_nand2b_1
XFILLER_104_116 VDD VSS sg13g2_decap_8
XFILLER_104_127 VDD VSS sg13g2_fill_1
X_4436_ _4436_/RESET_B VSS VDD _4436_/D _4436_/Q _4931_/CLK sg13g2_dfrbpq_1
X_4300__426 VDD VSS _4300_/RESET_B sg13g2_tiehi
XFILLER_59_704 VDD VSS sg13g2_fill_1
X_4367_ _4367_/RESET_B VSS VDD _4367_/D _4367_/Q _4973_/CLK sg13g2_dfrbpq_1
XFILLER_99_862 VDD VSS sg13g2_decap_8
XFILLER_101_823 VDD VSS sg13g2_decap_8
XFILLER_112_160 VDD VSS sg13g2_decap_8
XFILLER_113_683 VDD VSS sg13g2_decap_4
X_3318_ _3329_/A _4784_/Q _3319_/D VDD VSS sg13g2_nor2_1
X_4298_ _4298_/RESET_B VSS VDD _4298_/D _4298_/Q _4967_/CLK sg13g2_dfrbpq_1
XFILLER_39_450 VDD VSS sg13g2_decap_8
XFILLER_46_409 VDD VSS sg13g2_decap_4
XFILLER_55_910 VDD VSS sg13g2_decap_8
X_3249_ _3249_/Y _3249_/A _3249_/B VDD VSS sg13g2_xnor2_1
XFILLER_86_589 VDD VSS sg13g2_decap_4
XFILLER_86_578 VDD VSS sg13g2_fill_2
XFILLER_26_111 VDD VSS sg13g2_fill_1
XFILLER_26_133 VDD VSS sg13g2_decap_8
XFILLER_54_453 VDD VSS sg13g2_decap_8
XFILLER_70_913 VDD VSS sg13g2_decap_8
XFILLER_14_306 VDD VSS sg13g2_decap_8
XFILLER_42_615 VDD VSS sg13g2_decap_8
XFILLER_70_924 VDD VSS sg13g2_fill_2
XFILLER_10_578 VDD VSS sg13g2_decap_8
XFILLER_41_55 VDD VSS sg13g2_decap_8
XFILLER_6_538 VDD VSS sg13g2_decap_8
XFILLER_108_477 VDD VSS sg13g2_decap_8
XFILLER_2_722 VDD VSS sg13g2_decap_8
Xhold590 _4884_/Q VDD VSS _2561_/B sg13g2_dlygate4sd3_1
XFILLER_104_661 VDD VSS sg13g2_decap_8
XFILLER_110_119 VDD VSS sg13g2_decap_8
XFILLER_2_799 VDD VSS sg13g2_decap_8
XFILLER_77_523 VDD VSS sg13g2_fill_1
XFILLER_106_81 VDD VSS sg13g2_fill_1
XFILLER_2_49 VDD VSS sg13g2_decap_8
XFILLER_77_556 VDD VSS sg13g2_decap_8
XFILLER_89_394 VDD VSS sg13g2_decap_8
XFILLER_18_601 VDD VSS sg13g2_decap_4
XFILLER_66_63 VDD VSS sg13g2_decap_8
XFILLER_46_921 VDD VSS sg13g2_decap_4
XFILLER_64_228 VDD VSS sg13g2_decap_8
XFILLER_92_559 VDD VSS sg13g2_decap_8
Xhold1290 _4467_/Q VDD VSS _3552_/A1 sg13g2_dlygate4sd3_1
XFILLER_72_261 VDD VSS sg13g2_decap_8
XFILLER_82_40 VDD VSS sg13g2_decap_8
XFILLER_32_147 VDD VSS sg13g2_decap_8
XFILLER_60_456 VDD VSS sg13g2_decap_4
XFILLER_9_343 VDD VSS sg13g2_decap_8
X_2620_ _4855_/Q _3104_/S _2718_/B _2621_/A VDD VSS sg13g2_nor3_1
XFILLER_114_403 VDD VSS sg13g2_fill_1
XFILLER_115_915 VDD VSS sg13g2_decap_8
X_2551_ _2552_/C _4879_/Q _2551_/B VDD VSS sg13g2_nand2_1
X_2482_ _2485_/B _3944_/A _3954_/A _3954_/B VDD VSS sg13g2_and3_1
X_4221_ _4382_/Q _4407_/Q _4222_/A _4221_/X VDD VSS sg13g2_mux2_1
XFILLER_99_147 VDD VSS sg13g2_decap_8
XFILLER_87_309 VDD VSS sg13g2_decap_8
X_4152_ _2347_/A VDD _4152_/Y VSS _4205_/A1 _4450_/Q sg13g2_o21ai_1
XFILLER_49_770 VDD VSS sg13g2_decap_8
XFILLER_55_206 VDD VSS sg13g2_decap_8
XFILLER_83_504 VDD VSS sg13g2_decap_8
X_4083_ _4232_/B1 VDD _4083_/Y VSS _4205_/A1 _4443_/Q sg13g2_o21ai_1
X_3103_ _3103_/A0 _3128_/A _3104_/S _4527_/D VDD VSS sg13g2_mux2_1
XFILLER_96_898 VDD VSS sg13g2_decap_8
XFILLER_95_353 VDD VSS sg13g2_decap_8
XFILLER_110_697 VDD VSS sg13g2_decap_8
X_3034_ _3034_/A0 _4534_/Q _3034_/S _3034_/X VDD VSS sg13g2_mux2_1
XFILLER_102_28 VDD VSS sg13g2_decap_8
XFILLER_36_453 VDD VSS sg13g2_decap_8
XFILLER_83_559 VDD VSS sg13g2_decap_4
XFILLER_23_103 VDD VSS sg13g2_decap_8
XFILLER_52_913 VDD VSS sg13g2_decap_8
XFILLER_52_924 VDD VSS sg13g2_fill_2
XFILLER_23_125 VDD VSS sg13g2_fill_2
XFILLER_23_136 VDD VSS sg13g2_decap_8
XFILLER_24_648 VDD VSS sg13g2_fill_2
XFILLER_63_294 VDD VSS sg13g2_decap_8
XFILLER_20_810 VDD VSS sg13g2_decap_4
X_3936_ _3936_/A _3936_/B _3936_/C _3944_/C VDD VSS sg13g2_nor3_1
XFILLER_31_191 VDD VSS sg13g2_decap_8
X_3867_ _3868_/A _3868_/B _3867_/X VDD VSS sg13g2_and2_1
XFILLER_11_14 VDD VSS sg13g2_decap_8
XFILLER_20_898 VDD VSS sg13g2_fill_2
X_3798_ _3826_/A _3826_/B _3832_/B VDD VSS _4765_/Q sg13g2_nand3b_1
X_2818_ _4924_/D _2819_/B _2818_/B _2818_/C VDD VSS sg13g2_and3_1
X_2749_ _2749_/A _2749_/B _2751_/B _2749_/Y VDD VSS sg13g2_nor3_1
XFILLER_105_436 VDD VSS sg13g2_fill_2
XFILLER_11_69 VDD VSS sg13g2_decap_8
XFILLER_105_469 VDD VSS sg13g2_decap_8
XFILLER_59_512 VDD VSS sg13g2_decap_4
Xfanout300 fanout337/X fanout300/X VDD VSS sg13g2_buf_1
Xfanout311 fanout337/X fanout311/X VDD VSS sg13g2_buf_1
Xfanout322 fanout324/X fanout322/X VDD VSS sg13g2_buf_1
X_4419_ _4419_/RESET_B VSS VDD _4419_/D _4419_/Q _4817_/CLK sg13g2_dfrbpq_1
XFILLER_87_821 VDD VSS sg13g2_decap_4
XFILLER_101_631 VDD VSS sg13g2_decap_8
Xfanout333 fanout335/X fanout333/X VDD VSS sg13g2_buf_1
XFILLER_100_130 VDD VSS sg13g2_decap_8
XFILLER_74_504 VDD VSS sg13g2_decap_8
XFILLER_86_342 VDD VSS sg13g2_fill_2
XFILLER_46_217 VDD VSS sg13g2_fill_1
XFILLER_86_386 VDD VSS sg13g2_decap_8
XFILLER_27_475 VDD VSS sg13g2_decap_8
XFILLER_43_924 VDD VSS sg13g2_fill_2
XFILLER_55_795 VDD VSS sg13g2_decap_8
XFILLER_14_114 VDD VSS sg13g2_decap_8
XFILLER_36_99 VDD VSS sg13g2_decap_8
XFILLER_42_423 VDD VSS sg13g2_decap_8
XFILLER_14_147 VDD VSS sg13g2_fill_2
XFILLER_52_21 VDD VSS sg13g2_decap_8
XFILLER_11_832 VDD VSS sg13g2_fill_1
XFILLER_109_742 VDD VSS sg13g2_decap_8
XFILLER_10_364 VDD VSS sg13g2_decap_8
XFILLER_11_887 VDD VSS sg13g2_decap_8
XFILLER_7_858 VDD VSS sg13g2_decap_8
XFILLER_108_230 VDD VSS sg13g2_decap_8
XFILLER_6_368 VDD VSS sg13g2_decap_8
XFILLER_109_797 VDD VSS sg13g2_decap_8
XFILLER_46_762 VDD VSS sg13g2_decap_8
XFILLER_61_710 VDD VSS sg13g2_fill_2
XFILLER_60_231 VDD VSS sg13g2_fill_2
XFILLER_33_467 VDD VSS sg13g2_decap_8
XFILLER_60_264 VDD VSS sg13g2_decap_8
XFILLER_61_765 VDD VSS sg13g2_decap_8
XFILLER_60_286 VDD VSS sg13g2_fill_1
X_4770_ fanout246/X VSS VDD _4770_/D _4770_/Q clkload1/A sg13g2_dfrbpq_1
X_3721_ VSS VDD _3639_/X _3718_/C _3722_/B _3719_/B sg13g2_a21oi_1
X_3652_ _3652_/A0 _3652_/A1 _3652_/S _4747_/D VDD VSS sg13g2_mux2_1
XFILLER_9_184 VDD VSS sg13g2_fill_2
X_3583_ _4720_/Q _3587_/D _4721_/Q _3588_/B VDD VSS sg13g2_nand3_1
X_2603_ _2603_/A _2603_/B _2603_/C _3234_/B _2603_/Y VDD VSS sg13g2_nor4_1
X_2534_ _3789_/B _3728_/A _4903_/D VDD VSS sg13g2_nor2b_1
XFILLER_103_918 VDD VSS sg13g2_decap_8
XFILLER_47_0 VDD VSS sg13g2_decap_8
X_2465_ VSS VDD _2721_/C _3972_/D _4840_/D _2459_/Y sg13g2_a21oi_1
XFILLER_114_299 VDD VSS sg13g2_fill_1
X_4204_ _4233_/S _4430_/Q _4204_/Y VDD VSS sg13g2_nor2_1
X_2396_ VSS VDD _2396_/X _4917_/Q _4918_/Q sg13g2_or2_1
XFILLER_87_128 VDD VSS sg13g2_decap_8
XFILLER_29_729 VDD VSS sg13g2_decap_8
XFILLER_68_353 VDD VSS sg13g2_fill_2
X_4135_ _4243_/B1 VDD _4135_/Y VSS _4133_/Y _4134_/Y sg13g2_o21ai_1
XFILLER_110_461 VDD VSS sg13g2_decap_8
XFILLER_71_507 VDD VSS sg13g2_fill_2
XFILLER_84_868 VDD VSS sg13g2_decap_8
XFILLER_84_879 VDD VSS sg13g2_decap_8
X_4066_ _4066_/Y _4066_/B _4147_/B1 VDD VSS sg13g2_nand2b_1
XFILLER_95_194 VDD VSS sg13g2_decap_8
XFILLER_36_261 VDD VSS sg13g2_fill_2
XFILLER_37_773 VDD VSS sg13g2_decap_8
XFILLER_52_721 VDD VSS sg13g2_decap_8
XFILLER_71_529 VDD VSS sg13g2_decap_8
XFILLER_83_378 VDD VSS sg13g2_decap_8
X_3017_ _3017_/A0 _3017_/A1 _3029_/S _4443_/D VDD VSS sg13g2_mux2_1
XFILLER_36_294 VDD VSS sg13g2_decap_8
XFILLER_52_787 VDD VSS sg13g2_decap_8
X_4968_ fanout296/X VSS VDD _4968_/D _4968_/Q _4968_/CLK sg13g2_dfrbpq_1
X_4899_ fanout246/X VSS VDD _4899_/D _4899_/Q _4904_/CLK sg13g2_dfrbpq_1
X_3919_ _3922_/A _3919_/C _3919_/A _3924_/C VDD VSS sg13g2_nand3_1
XFILLER_20_662 VDD VSS sg13g2_decap_8
Xfanout130 _3082_/S _3079_/S VDD VSS sg13g2_buf_1
XFILLER_47_21 VDD VSS sg13g2_fill_1
Xfanout141 _2346_/Y _4188_/A1 VDD VSS sg13g2_buf_1
Xfanout152 _3057_/S _3056_/S VDD VSS sg13g2_buf_1
Xfanout163 fanout165/X _4121_/A VDD VSS sg13g2_buf_1
Xfanout174 _4243_/B1 _4227_/A1 VDD VSS sg13g2_buf_1
XFILLER_93_109 VDD VSS sg13g2_fill_1
Xfanout185 fanout188/X _4250_/B1 VDD VSS sg13g2_buf_1
Xfanout196 _4222_/A _4052_/A VDD VSS sg13g2_buf_1
XFILLER_87_684 VDD VSS sg13g2_decap_8
XFILLER_62_507 VDD VSS sg13g2_decap_4
XFILLER_15_401 VDD VSS sg13g2_decap_8
XFILLER_28_795 VDD VSS sg13g2_decap_8
XFILLER_90_838 VDD VSS sg13g2_decap_8
XFILLER_42_220 VDD VSS sg13g2_decap_4
XFILLER_43_721 VDD VSS sg13g2_decap_8
XFILLER_63_42 VDD VSS sg13g2_decap_8
XFILLER_15_478 VDD VSS sg13g2_fill_2
XFILLER_30_426 VDD VSS sg13g2_decap_8
XFILLER_70_595 VDD VSS sg13g2_decap_8
XFILLER_10_150 VDD VSS sg13g2_decap_8
XFILLER_7_633 VDD VSS sg13g2_decap_8
XFILLER_109_550 VDD VSS sg13g2_decap_4
XFILLER_7_644 VDD VSS sg13g2_fill_1
XFILLER_12_90 VDD VSS sg13g2_fill_1
XFILLER_6_198 VDD VSS sg13g2_decap_8
XFILLER_111_203 VDD VSS sg13g2_decap_8
XFILLER_40_7 VDD VSS sg13g2_decap_8
X_2250_ VDD _3954_/A _3944_/B VSS sg13g2_inv_1
XFILLER_97_448 VDD VSS sg13g2_decap_8
XFILLER_88_83 VDD VSS sg13g2_decap_8
XFILLER_65_323 VDD VSS sg13g2_fill_2
XFILLER_66_824 VDD VSS sg13g2_decap_8
XFILLER_78_695 VDD VSS sg13g2_decap_4
XFILLER_77_194 VDD VSS sg13g2_decap_8
XFILLER_93_643 VDD VSS sg13g2_decap_8
XFILLER_92_131 VDD VSS sg13g2_decap_8
XFILLER_81_849 VDD VSS sg13g2_decap_8
XFILLER_18_294 VDD VSS sg13g2_decap_8
XFILLER_19_795 VDD VSS sg13g2_decap_8
XFILLER_80_359 VDD VSS sg13g2_fill_1
XFILLER_33_242 VDD VSS sg13g2_decap_8
XFILLER_21_415 VDD VSS sg13g2_fill_2
XFILLER_33_286 VDD VSS sg13g2_fill_2
XFILLER_33_297 VDD VSS sg13g2_fill_2
X_4822_ fanout313/X VSS VDD _4822_/D _4822_/Q _4824_/CLK sg13g2_dfrbpq_1
X_4753_ fanout271/X VSS VDD _4753_/D _4753_/Q _4942_/CLK sg13g2_dfrbpq_1
X_3704_ VSS VDD _3983_/B _3726_/B _3704_/Y _3703_/Y sg13g2_a21oi_1
X_4684_ fanout310/X VSS VDD _4684_/D _4684_/Q _4869_/CLK sg13g2_dfrbpq_1
X_3635_ _3694_/A _3635_/B _3698_/C VDD VSS sg13g2_and2_1
X_3566_ _3558_/A VDD _3568_/B VSS _2708_/B _3565_/Y sg13g2_o21ai_1
XFILLER_0_319 VDD VSS sg13g2_decap_8
XFILLER_103_704 VDD VSS sg13g2_decap_8
XFILLER_103_715 VDD VSS sg13g2_fill_1
X_3497_ _4861_/Q _4860_/Q _3498_/B VDD VSS sg13g2_nor2_1
X_2517_ VDD _2517_/Y _3144_/A VSS sg13g2_inv_1
XFILLER_103_759 VDD VSS sg13g2_decap_8
X_2448_ _3691_/A _3688_/A _2448_/B VDD VSS sg13g2_nand2_1
XFILLER_88_426 VDD VSS sg13g2_decap_8
XFILLER_69_662 VDD VSS sg13g2_decap_4
XFILLER_75_109 VDD VSS sg13g2_fill_2
XFILLER_29_537 VDD VSS sg13g2_decap_4
XFILLER_56_301 VDD VSS sg13g2_decap_8
XFILLER_69_695 VDD VSS sg13g2_fill_2
XFILLER_84_610 VDD VSS sg13g2_decap_8
X_2379_ _3394_/A _4648_/Q _2379_/C _2379_/D _2389_/A VDD VSS sg13g2_nor4_1
XFILLER_56_345 VDD VSS sg13g2_decap_8
XFILLER_57_879 VDD VSS sg13g2_decap_8
XFILLER_72_805 VDD VSS sg13g2_fill_1
XFILLER_83_142 VDD VSS sg13g2_decap_8
X_4118_ _4271_/Q _4296_/Q _4118_/S _4118_/X VDD VSS sg13g2_mux2_1
XFILLER_56_389 VDD VSS sg13g2_decap_8
XFILLER_71_315 VDD VSS sg13g2_decap_8
XFILLER_84_687 VDD VSS sg13g2_fill_2
X_4049_ VSS VDD _4253_/A1 _4048_/X _4049_/Y _4218_/A1 sg13g2_a21oi_1
XFILLER_17_68 VDD VSS sg13g2_decap_8
XFILLER_65_890 VDD VSS sg13g2_decap_8
XFILLER_71_348 VDD VSS sg13g2_fill_1
XFILLER_24_231 VDD VSS sg13g2_decap_8
XFILLER_24_242 VDD VSS sg13g2_fill_1
XFILLER_25_754 VDD VSS sg13g2_decap_8
XFILLER_52_540 VDD VSS sg13g2_fill_1
XFILLER_33_23 VDD VSS sg13g2_fill_1
XFILLER_40_724 VDD VSS sg13g2_decap_4
XFILLER_33_56 VDD VSS sg13g2_fill_1
XFILLER_40_779 VDD VSS sg13g2_decap_8
XFILLER_8_419 VDD VSS sg13g2_decap_8
XFILLER_33_89 VDD VSS sg13g2_decap_8
XFILLER_20_470 VDD VSS sg13g2_decap_8
XFILLER_106_531 VDD VSS sg13g2_decap_8
XFILLER_0_886 VDD VSS sg13g2_decap_8
XFILLER_102_770 VDD VSS sg13g2_decap_8
XFILLER_58_75 VDD VSS sg13g2_decap_4
XFILLER_59_172 VDD VSS sg13g2_decap_8
XFILLER_47_356 VDD VSS sg13g2_decap_8
XFILLER_48_857 VDD VSS sg13g2_decap_8
XFILLER_74_120 VDD VSS sg13g2_decap_4
XFILLER_35_529 VDD VSS sg13g2_fill_1
XFILLER_47_367 VDD VSS sg13g2_fill_2
XFILLER_74_164 VDD VSS sg13g2_fill_1
XFILLER_75_698 VDD VSS sg13g2_decap_8
XFILLER_28_592 VDD VSS sg13g2_decap_8
XFILLER_63_849 VDD VSS sg13g2_decap_8
XFILLER_74_85 VDD VSS sg13g2_decap_8
XFILLER_15_253 VDD VSS sg13g2_decap_4
XFILLER_90_668 VDD VSS sg13g2_decap_8
XFILLER_30_201 VDD VSS sg13g2_decap_8
XFILLER_70_381 VDD VSS sg13g2_decap_8
XFILLER_71_882 VDD VSS sg13g2_decap_8
XFILLER_31_768 VDD VSS sg13g2_decap_8
XFILLER_88_7 VDD VSS sg13g2_decap_8
XFILLER_116_317 VDD VSS sg13g2_decap_8
XFILLER_7_474 VDD VSS sg13g2_decap_8
XFILLER_109_380 VDD VSS sg13g2_decap_8
X_3420_ _3420_/B _3420_/C _3420_/A _3421_/C VDD VSS _3420_/D sg13g2_nand4_1
X_3351_ _3353_/A _3357_/B _3469_/C _3360_/B VDD VSS sg13g2_and3_1
XFILLER_112_523 VDD VSS sg13g2_decap_8
X_2302_ VDD _3206_/A _2302_/A VSS sg13g2_inv_1
XFILLER_100_718 VDD VSS sg13g2_decap_4
XFILLER_112_545 VDD VSS sg13g2_fill_1
XFILLER_39_802 VDD VSS sg13g2_fill_1
X_3282_ _2617_/B VDD _3282_/Y VSS _4618_/Q _3280_/B sg13g2_o21ai_1
XFILLER_66_610 VDD VSS sg13g2_decap_8
Xhold1108 _4968_/Q VDD VSS _4148_/B sg13g2_dlygate4sd3_1
Xhold1119 _4350_/Q VDD VSS _2918_/A0 sg13g2_dlygate4sd3_1
X_2233_ VDD _4897_/D input1/X VSS sg13g2_inv_1
XFILLER_97_289 VDD VSS sg13g2_decap_8
XFILLER_85_429 VDD VSS sg13g2_decap_8
XFILLER_38_345 VDD VSS sg13g2_decap_4
XFILLER_54_805 VDD VSS sg13g2_decap_8
XFILLER_26_518 VDD VSS sg13g2_fill_1
XFILLER_19_570 VDD VSS sg13g2_decap_8
XFILLER_53_348 VDD VSS sg13g2_fill_2
XFILLER_80_112 VDD VSS sg13g2_decap_8
XFILLER_81_646 VDD VSS sg13g2_decap_8
XFILLER_93_495 VDD VSS sg13g2_decap_8
XFILLER_110_28 VDD VSS sg13g2_decap_8
XFILLER_34_573 VDD VSS sg13g2_decap_8
XFILLER_62_893 VDD VSS sg13g2_fill_2
XFILLER_61_392 VDD VSS sg13g2_decap_8
X_4805_ fanout290/X VSS VDD _4805_/D _4805_/Q _4807_/CLK sg13g2_dfrbpq_1
X_2997_ _4142_/B _3023_/A1 _3003_/S _2997_/X VDD VSS sg13g2_mux2_1
X_4736_ fanout284/X VSS VDD _4736_/D _4736_/Q _4737_/CLK sg13g2_dfrbpq_1
XFILLER_107_328 VDD VSS sg13g2_decap_8
XFILLER_108_829 VDD VSS sg13g2_decap_8
X_4667_ fanout272/X VSS VDD _4667_/D _4667_/Q _4745_/CLK sg13g2_dfrbpq_1
Xhold931 _4500_/Q VDD VSS hold931/X sg13g2_dlygate4sd3_1
Xhold920 _2953_/X VDD VSS _4383_/D sg13g2_dlygate4sd3_1
X_3618_ _3618_/A0 _3618_/A1 _3654_/S _4730_/D VDD VSS sg13g2_mux2_1
XFILLER_116_873 VDD VSS sg13g2_decap_8
Xhold942 _4314_/Q VDD VSS hold942/X sg13g2_dlygate4sd3_1
Xhold953 _2854_/X VDD VSS _4289_/D sg13g2_dlygate4sd3_1
Xhold964 _4378_/Q VDD VSS hold964/X sg13g2_dlygate4sd3_1
X_4598_ fanout289/X VSS VDD _4598_/D _4598_/Q _4601_/CLK sg13g2_dfrbpq_1
XFILLER_0_105 VDD VSS sg13g2_decap_8
Xhold975 _4260_/Q VDD VSS _2450_/B sg13g2_dlygate4sd3_1
Xhold986 _2954_/X VDD VSS _4384_/D sg13g2_dlygate4sd3_1
Xhold997 _4442_/Q VDD VSS hold997/X sg13g2_dlygate4sd3_1
X_3549_ hold966/X hold849/X _3551_/S _4711_/D VDD VSS sg13g2_mux2_1
XFILLER_89_735 VDD VSS sg13g2_decap_8
XFILLER_103_567 VDD VSS sg13g2_decap_8
XFILLER_88_256 VDD VSS sg13g2_decap_8
XFILLER_29_345 VDD VSS sg13g2_decap_8
Xhold1620 _4788_/Q VDD VSS _2312_/A sg13g2_dlygate4sd3_1
Xhold1631 _3596_/A VDD VSS _2707_/A sg13g2_dlygate4sd3_1
Xhold1642 _4781_/Q VDD VSS _2323_/A sg13g2_dlygate4sd3_1
Xhold1653 _4648_/Q VDD VSS _3422_/A0 sg13g2_dlygate4sd3_1
XFILLER_17_529 VDD VSS sg13g2_decap_8
XFILLER_57_676 VDD VSS sg13g2_decap_8
Xhold1664 _4716_/Q VDD VSS hold1664/X sg13g2_dlygate4sd3_1
Xhold1675 _4758_/Q VDD VSS _2524_/D sg13g2_dlygate4sd3_1
XFILLER_72_657 VDD VSS sg13g2_decap_8
XFILLER_13_735 VDD VSS sg13g2_decap_4
XFILLER_44_77 VDD VSS sg13g2_decap_8
XFILLER_71_189 VDD VSS sg13g2_decap_8
XFILLER_60_21 VDD VSS sg13g2_decap_8
XFILLER_8_216 VDD VSS sg13g2_decap_8
Xclkbuf_4_0_0_clk clkbuf_0_clk/X clkbuf_4_0_0_clk/X VDD VSS sg13g2_buf_8
XFILLER_106_383 VDD VSS sg13g2_fill_1
XFILLER_107_895 VDD VSS sg13g2_fill_1
XFILLER_79_223 VDD VSS sg13g2_decap_8
XFILLER_0_683 VDD VSS sg13g2_decap_8
XFILLER_47_120 VDD VSS sg13g2_decap_8
XFILLER_47_131 VDD VSS sg13g2_fill_2
XFILLER_36_816 VDD VSS sg13g2_decap_8
XFILLER_75_462 VDD VSS sg13g2_fill_1
XFILLER_91_911 VDD VSS sg13g2_decap_8
XFILLER_85_73 VDD VSS sg13g2_decap_8
XFILLER_35_315 VDD VSS sg13g2_decap_8
XFILLER_48_698 VDD VSS sg13g2_fill_1
XFILLER_62_101 VDD VSS sg13g2_decap_8
XFILLER_90_410 VDD VSS sg13g2_decap_8
XFILLER_44_860 VDD VSS sg13g2_decap_8
XFILLER_51_808 VDD VSS sg13g2_decap_8
X_2920_ _2920_/A0 _3026_/A1 _2927_/S _2920_/X VDD VSS sg13g2_mux2_1
XFILLER_31_543 VDD VSS sg13g2_decap_8
X_2851_ _2851_/A0 _3086_/A0 _2875_/S _4286_/D VDD VSS sg13g2_mux2_1
X_2782_ _2782_/A _2782_/B _2782_/Y VDD VSS sg13g2_nor2_1
XFILLER_8_750 VDD VSS sg13g2_decap_8
X_4521_ fanout296/X VSS VDD _4521_/D _4521_/Q _4960_/CLK sg13g2_dfrbpq_1
X_4452_ _4452_/RESET_B VSS VDD _4452_/D _4452_/Q _4971_/CLK sg13g2_dfrbpq_1
XFILLER_116_158 VDD VSS sg13g2_decap_8
X_3403_ _4790_/Q VDD _3403_/Y VSS _3329_/A _3413_/C sg13g2_o21ai_1
X_4383_ _4383_/RESET_B VSS VDD _4383_/D _4383_/Q _4877_/CLK sg13g2_dfrbpq_1
XFILLER_98_532 VDD VSS sg13g2_decap_8
XFILLER_113_865 VDD VSS sg13g2_fill_2
X_3334_ _4781_/Q _4779_/Q _4780_/Q _3334_/Y VDD VSS sg13g2_nand3_1
XFILLER_39_610 VDD VSS sg13g2_fill_1
X_3265_ _3265_/Y _3265_/B _2615_/C VDD VSS sg13g2_nand2b_1
XFILLER_98_598 VDD VSS sg13g2_fill_2
XFILLER_100_559 VDD VSS sg13g2_decap_8
XFILLER_38_131 VDD VSS sg13g2_decap_8
X_3196_ _2645_/A VDD _4582_/D VSS _3193_/B _3195_/X sg13g2_o21ai_1
XFILLER_38_186 VDD VSS sg13g2_decap_8
XFILLER_94_793 VDD VSS sg13g2_decap_8
XFILLER_26_348 VDD VSS sg13g2_fill_2
XFILLER_54_679 VDD VSS sg13g2_fill_1
XFILLER_35_882 VDD VSS sg13g2_decap_4
XFILLER_14_14 VDD VSS sg13g2_decap_8
XFILLER_50_885 VDD VSS sg13g2_fill_1
XFILLER_22_598 VDD VSS sg13g2_decap_8
X_4719_ fanout327/X VSS VDD _4719_/D _4719_/Q _4870_/CLK sg13g2_dfrbpq_1
XFILLER_107_125 VDD VSS sg13g2_decap_8
XFILLER_30_35 VDD VSS sg13g2_decap_4
XFILLER_2_904 VDD VSS sg13g2_decap_8
Xhold772 _3282_/Y VDD VSS hold772/X sg13g2_dlygate4sd3_1
Xhold761 _3160_/Y VDD VSS hold761/X sg13g2_dlygate4sd3_1
Xhold750 _4936_/Q VDD VSS _2760_/B sg13g2_dlygate4sd3_1
XFILLER_1_436 VDD VSS sg13g2_fill_2
Xhold794 _4509_/Q VDD VSS hold794/X sg13g2_dlygate4sd3_1
Xhold783 _4131_/Y VDD VSS _4966_/D sg13g2_dlygate4sd3_1
XFILLER_89_598 VDD VSS sg13g2_decap_8
XFILLER_29_142 VDD VSS sg13g2_fill_1
Xhold1450 _3153_/Y VDD VSS _4563_/D sg13g2_dlygate4sd3_1
Xhold1461 _2745_/Y VDD VSS _2746_/B sg13g2_dlygate4sd3_1
XFILLER_92_719 VDD VSS sg13g2_fill_1
XFILLER_85_771 VDD VSS sg13g2_fill_1
XFILLER_45_635 VDD VSS sg13g2_decap_8
XFILLER_55_21 VDD VSS sg13g2_decap_8
Xhold1472 _4763_/Q VDD VSS _3749_/A sg13g2_dlygate4sd3_1
Xhold1483 _4618_/Q VDD VSS _3280_/A sg13g2_dlygate4sd3_1
Xhold1494 _3251_/Y VDD VSS _3252_/A2 sg13g2_dlygate4sd3_1
XFILLER_26_860 VDD VSS sg13g2_decap_8
XFILLER_72_432 VDD VSS sg13g2_decap_8
XFILLER_32_329 VDD VSS sg13g2_decap_8
XFILLER_44_178 VDD VSS sg13g2_decap_8
XFILLER_44_189 VDD VSS sg13g2_fill_1
XFILLER_41_852 VDD VSS sg13g2_decap_8
XFILLER_60_649 VDD VSS sg13g2_fill_2
XFILLER_40_362 VDD VSS sg13g2_decap_8
XFILLER_71_42 VDD VSS sg13g2_fill_2
XFILLER_71_53 VDD VSS sg13g2_fill_1
XFILLER_5_753 VDD VSS sg13g2_decap_8
XFILLER_107_692 VDD VSS sg13g2_decap_8
XFILLER_20_90 VDD VSS sg13g2_decap_8
XFILLER_4_296 VDD VSS sg13g2_decap_8
XFILLER_0_480 VDD VSS sg13g2_decap_8
X_3050_ _4476_/Q hold808/X _3056_/S _3050_/X VDD VSS sg13g2_mux2_1
XFILLER_96_83 VDD VSS sg13g2_decap_8
XFILLER_95_546 VDD VSS sg13g2_fill_2
XFILLER_48_462 VDD VSS sg13g2_decap_8
XFILLER_17_860 VDD VSS sg13g2_decap_8
XFILLER_51_616 VDD VSS sg13g2_fill_1
XFILLER_90_262 VDD VSS sg13g2_fill_2
XFILLER_16_392 VDD VSS sg13g2_fill_2
X_3952_ _3952_/B1 VDD _3953_/B VSS _3954_/D _3951_/B sg13g2_o21ai_1
X_3883_ VSS VDD _3889_/C _3905_/C _3883_/Y _2476_/A sg13g2_a21oi_1
X_2903_ _3009_/A _2903_/B _2903_/Y VDD VSS sg13g2_nor2_1
XFILLER_31_384 VDD VSS sg13g2_decap_8
X_2834_ _2834_/A0 _3096_/A0 _2842_/S _2834_/X VDD VSS sg13g2_mux2_1
XFILLER_77_0 VDD VSS sg13g2_decap_8
X_4504_ fanout301/X VSS VDD _4504_/D _4504_/Q _4974_/CLK sg13g2_dfrbpq_1
X_2765_ _2766_/A _2766_/B _2767_/B VDD VSS sg13g2_nor2_1
XFILLER_8_591 VDD VSS sg13g2_decap_8
XFILLER_105_607 VDD VSS sg13g2_decap_8
X_2696_ _2696_/B _2696_/C _2696_/A _2696_/Y VDD VSS sg13g2_nand3_1
XFILLER_6_92 VDD VSS sg13g2_decap_8
X_4435_ _4435_/RESET_B VSS VDD _4435_/D _4435_/Q _4961_/CLK sg13g2_dfrbpq_1
XFILLER_116_49 VDD VSS sg13g2_decap_8
X_4366_ _4366_/RESET_B VSS VDD _4366_/D _4366_/Q _4960_/CLK sg13g2_dfrbpq_1
XFILLER_101_802 VDD VSS sg13g2_decap_8
X_3317_ _4783_/Q _4780_/Q _4781_/Q _3396_/C VDD VSS sg13g2_nor3_1
XFILLER_98_384 VDD VSS sg13g2_decap_8
XFILLER_100_334 VDD VSS sg13g2_decap_8
X_4297_ _4297_/RESET_B VSS VDD _4297_/D _4297_/Q _4397_/CLK sg13g2_dfrbpq_1
XFILLER_86_535 VDD VSS sg13g2_fill_2
XFILLER_101_879 VDD VSS sg13g2_decap_4
X_3248_ VSS VDD _3248_/A1 _3247_/Y _3248_/Y _3289_/A sg13g2_a21oi_1
XFILLER_66_270 VDD VSS sg13g2_decap_8
XFILLER_66_281 VDD VSS sg13g2_fill_2
XFILLER_67_793 VDD VSS sg13g2_decap_8
X_3179_ VSS VDD _3181_/B _3178_/Y _3179_/Y _3179_/B1 sg13g2_a21oi_1
XFILLER_27_668 VDD VSS sg13g2_decap_8
XFILLER_27_679 VDD VSS sg13g2_fill_2
XFILLER_54_432 VDD VSS sg13g2_decap_8
XFILLER_25_35 VDD VSS sg13g2_decap_8
XFILLER_26_189 VDD VSS sg13g2_fill_2
XFILLER_82_774 VDD VSS sg13g2_decap_8
XFILLER_81_284 VDD VSS sg13g2_decap_8
XFILLER_109_913 VDD VSS sg13g2_decap_8
XFILLER_109_924 VDD VSS sg13g2_fill_2
XFILLER_6_517 VDD VSS sg13g2_fill_2
XFILLER_41_89 VDD VSS sg13g2_decap_4
XFILLER_6_528 VDD VSS sg13g2_fill_1
XFILLER_2_701 VDD VSS sg13g2_decap_8
XFILLER_104_640 VDD VSS sg13g2_decap_8
XFILLER_1_222 VDD VSS sg13g2_decap_8
XFILLER_1_233 VDD VSS sg13g2_fill_2
Xhold580 _4877_/Q VDD VSS _2547_/A sg13g2_dlygate4sd3_1
XFILLER_2_778 VDD VSS sg13g2_decap_8
Xhold591 _2560_/Y VDD VSS _2563_/A sg13g2_dlygate4sd3_1
XFILLER_89_373 VDD VSS sg13g2_decap_8
XFILLER_2_28 VDD VSS sg13g2_decap_8
XFILLER_77_535 VDD VSS sg13g2_decap_8
XFILLER_46_911 VDD VSS sg13g2_fill_1
XFILLER_66_42 VDD VSS sg13g2_decap_8
XFILLER_100_890 VDD VSS sg13g2_decap_8
XFILLER_57_270 VDD VSS sg13g2_decap_4
XFILLER_64_218 VDD VSS sg13g2_fill_1
XFILLER_92_538 VDD VSS sg13g2_fill_2
XFILLER_17_134 VDD VSS sg13g2_decap_8
Xhold1280 _4935_/Q VDD VSS _2766_/A sg13g2_dlygate4sd3_1
Xhold1291 _3552_/X VDD VSS _4714_/D sg13g2_dlygate4sd3_1
XFILLER_60_413 VDD VSS sg13g2_fill_2
XFILLER_61_914 VDD VSS sg13g2_decap_8
XFILLER_61_925 VDD VSS sg13g2_fill_1
XFILLER_73_796 VDD VSS sg13g2_decap_8
XFILLER_33_649 VDD VSS sg13g2_decap_4
XFILLER_13_362 VDD VSS sg13g2_decap_8
XFILLER_9_322 VDD VSS sg13g2_decap_8
XFILLER_70_7 VDD VSS sg13g2_fill_2
X_2550_ _2550_/B _2550_/A _2550_/X VDD VSS sg13g2_xor2_1
X_2481_ _3901_/D _3936_/A _2481_/C _2485_/A VDD VSS sg13g2_nor3_1
XFILLER_99_126 VDD VSS sg13g2_decap_8
X_4220_ _4219_/Y VDD _4220_/Y VSS _4217_/Y _4218_/Y sg13g2_o21ai_1
XFILLER_110_632 VDD VSS sg13g2_decap_8
XFILLER_68_557 VDD VSS sg13g2_decap_8
X_4151_ _4233_/S _4425_/Q _4151_/Y VDD VSS sg13g2_nor2_1
XFILLER_95_332 VDD VSS sg13g2_fill_1
XFILLER_95_321 VDD VSS sg13g2_decap_8
X_4082_ _4144_/S _4418_/Q _4082_/Y VDD VSS sg13g2_nor2_1
X_3102_ _4526_/Q _3127_/A1 _3109_/S _3102_/X VDD VSS sg13g2_mux2_1
XFILLER_96_877 VDD VSS sg13g2_decap_8
XFILLER_37_922 VDD VSS sg13g2_decap_4
XFILLER_83_538 VDD VSS sg13g2_decap_8
X_3033_ _3033_/A0 _3033_/A1 _3033_/S _4459_/D VDD VSS sg13g2_mux2_1
XFILLER_36_432 VDD VSS sg13g2_decap_8
XFILLER_63_273 VDD VSS sg13g2_decap_8
XFILLER_64_774 VDD VSS sg13g2_decap_4
XFILLER_91_582 VDD VSS sg13g2_decap_8
X_3935_ _3935_/B _3935_/C _3935_/A _3936_/C VDD VSS sg13g2_nand3_1
XFILLER_31_170 VDD VSS sg13g2_decap_8
XFILLER_20_877 VDD VSS sg13g2_decap_8
X_3866_ _3866_/A _3866_/B _3866_/C _3954_/C VDD VSS sg13g2_or3_1
X_3797_ _3829_/B _3826_/A _3826_/B VDD VSS sg13g2_nand2_1
X_2817_ _2814_/B _2814_/A _2413_/A _2818_/C VDD VSS sg13g2_a21o_1
XFILLER_106_916 VDD VSS sg13g2_decap_8
XFILLER_11_48 VDD VSS sg13g2_decap_8
X_2748_ _2751_/B _2748_/A _2748_/B _2748_/C VDD VSS sg13g2_and3_1
X_4418_ _4418_/RESET_B VSS VDD _4418_/D _4418_/Q clkload6/A sg13g2_dfrbpq_1
X_2679_ VSS VDD _2674_/Y _2675_/Y _2679_/Y _3511_/A sg13g2_a21oi_1
Xfanout301 fanout305/X fanout301/X VDD VSS sg13g2_buf_1
Xfanout312 fanout320/X fanout312/X VDD VSS sg13g2_buf_1
Xfanout323 fanout324/X fanout323/X VDD VSS sg13g2_buf_1
XFILLER_87_800 VDD VSS sg13g2_decap_8
XFILLER_101_621 VDD VSS sg13g2_fill_1
XFILLER_113_481 VDD VSS sg13g2_decap_8
Xfanout334 fanout335/X fanout334/X VDD VSS sg13g2_buf_1
X_4349_ _4349_/RESET_B VSS VDD _4349_/D _4349_/Q _4968_/CLK sg13g2_dfrbpq_1
XFILLER_98_170 VDD VSS sg13g2_decap_4
XFILLER_87_877 VDD VSS sg13g2_decap_4
XFILLER_100_186 VDD VSS sg13g2_decap_8
XFILLER_27_410 VDD VSS sg13g2_fill_1
XFILLER_28_911 VDD VSS sg13g2_decap_8
XFILLER_39_281 VDD VSS sg13g2_decap_8
XFILLER_36_78 VDD VSS sg13g2_decap_8
XFILLER_55_774 VDD VSS sg13g2_decap_8
XFILLER_30_619 VDD VSS sg13g2_decap_8
XFILLER_70_766 VDD VSS sg13g2_decap_8
XFILLER_23_693 VDD VSS sg13g2_decap_8
XFILLER_10_343 VDD VSS sg13g2_decap_8
XFILLER_11_866 VDD VSS sg13g2_decap_8
XFILLER_22_192 VDD VSS sg13g2_fill_2
XFILLER_50_490 VDD VSS sg13g2_decap_8
XFILLER_52_77 VDD VSS sg13g2_decap_8
XFILLER_7_804 VDD VSS sg13g2_decap_8
XFILLER_109_721 VDD VSS sg13g2_decap_8
XFILLER_7_837 VDD VSS sg13g2_decap_8
XFILLER_109_765 VDD VSS sg13g2_fill_1
XFILLER_109_776 VDD VSS sg13g2_decap_8
XFILLER_7_0 VDD VSS sg13g2_decap_4
XFILLER_112_919 VDD VSS sg13g2_decap_8
XFILLER_2_553 VDD VSS sg13g2_decap_8
XFILLER_2_564 VDD VSS sg13g2_fill_1
XFILLER_104_492 VDD VSS sg13g2_fill_1
XFILLER_28_9 VDD VSS sg13g2_fill_1
XFILLER_78_877 VDD VSS sg13g2_decap_8
XFILLER_19_922 VDD VSS sg13g2_decap_4
XFILLER_37_229 VDD VSS sg13g2_decap_8
XFILLER_77_387 VDD VSS sg13g2_decap_8
XFILLER_93_836 VDD VSS sg13g2_decap_4
XFILLER_92_324 VDD VSS sg13g2_fill_1
XFILLER_92_313 VDD VSS sg13g2_decap_8
XFILLER_46_730 VDD VSS sg13g2_fill_1
XFILLER_46_741 VDD VSS sg13g2_decap_8
XFILLER_65_549 VDD VSS sg13g2_decap_8
XFILLER_93_869 VDD VSS sg13g2_decap_8
XFILLER_93_51 VDD VSS sg13g2_decap_4
XFILLER_33_402 VDD VSS sg13g2_fill_2
XFILLER_33_446 VDD VSS sg13g2_decap_8
XFILLER_93_95 VDD VSS sg13g2_decap_8
XFILLER_60_243 VDD VSS sg13g2_decap_8
XFILLER_14_693 VDD VSS sg13g2_decap_8
XFILLER_60_276 VDD VSS sg13g2_fill_1
X_3720_ _3720_/Y _3715_/Y _3719_/X _3726_/B _3991_/B VDD VSS sg13g2_a22oi_1
Xclkbuf_leaf_40_clk clkbuf_4_9_0_clk/X _4976_/CLK VDD VSS sg13g2_buf_8
X_3651_ _3651_/A0 _3651_/A1 _3652_/S _4746_/D VDD VSS sg13g2_mux2_1
XFILLER_9_163 VDD VSS sg13g2_decap_8
X_3582_ _3590_/C _3582_/B _3582_/C _3600_/A VDD VSS sg13g2_or3_1
X_2602_ _2602_/Y _2602_/A _3232_/B VDD VSS sg13g2_nand2_1
X_2533_ _3807_/A _3807_/B _3789_/B VDD VSS sg13g2_nor2_1
XFILLER_114_223 VDD VSS sg13g2_decap_4
XFILLER_88_608 VDD VSS sg13g2_decap_4
XFILLER_69_811 VDD VSS sg13g2_decap_8
X_2464_ _2464_/A _2464_/B _2464_/C _2464_/D _2722_/A VDD VSS sg13g2_and4_1
XFILLER_87_107 VDD VSS sg13g2_decap_8
X_4203_ _4380_/Q _4405_/Q _4233_/S _4203_/X VDD VSS sg13g2_mux2_1
X_2395_ _2434_/A _2395_/A _2395_/B VDD VSS sg13g2_nand2_1
XFILLER_110_440 VDD VSS sg13g2_decap_8
XFILLER_29_708 VDD VSS sg13g2_decap_8
XFILLER_68_332 VDD VSS sg13g2_decap_8
X_4134_ _4172_/S1 VDD _4134_/Y VSS _4241_/A1 _4448_/Q sg13g2_o21ai_1
XFILLER_56_538 VDD VSS sg13g2_decap_8
XFILLER_37_730 VDD VSS sg13g2_decap_8
XFILLER_56_549 VDD VSS sg13g2_fill_2
X_4065_ _4147_/B1 VDD _4065_/Y VSS _4245_/A1 _4059_/X sg13g2_o21ai_1
XFILLER_36_240 VDD VSS sg13g2_decap_4
X_3016_ hold997/X _4516_/Q _3034_/S _3016_/X VDD VSS sg13g2_mux2_1
XFILLER_24_413 VDD VSS sg13g2_decap_8
XFILLER_36_273 VDD VSS sg13g2_decap_8
XFILLER_11_118 VDD VSS sg13g2_decap_8
XFILLER_11_129 VDD VSS sg13g2_fill_2
X_4967_ fanout307/X VSS VDD _4967_/D _4967_/Q _4967_/CLK sg13g2_dfrbpq_1
XFILLER_20_641 VDD VSS sg13g2_decap_8
Xclkbuf_leaf_31_clk clkbuf_4_15_0_clk/X _4941_/CLK VDD VSS sg13g2_buf_8
X_4898_ fanout257/X VSS VDD _4898_/D _4898_/Q _4907_/CLK sg13g2_dfrbpq_1
X_3918_ _3918_/B _3919_/A _4811_/Q _3936_/B VDD VSS _3918_/D sg13g2_nand4_1
X_3849_ _3849_/Y _3852_/A _3848_/Y _3791_/S _3405_/B VDD VSS sg13g2_a22oi_1
XFILLER_106_702 VDD VSS sg13g2_decap_4
XFILLER_0_7 VDD VSS sg13g2_decap_8
XFILLER_105_256 VDD VSS sg13g2_decap_8
XFILLER_78_107 VDD VSS sg13g2_fill_2
Xfanout120 _3654_/S _3652_/S VDD VSS sg13g2_buf_1
Xfanout131 _2467_/Y _3082_/S VDD VSS sg13g2_buf_1
Xfanout142 _2308_/Y _3278_/A VDD VSS sg13g2_buf_1
Xfanout153 _3058_/S _3057_/S VDD VSS sg13g2_buf_1
Xfanout164 fanout165/X _4930_/D VDD VSS sg13g2_buf_1
XFILLER_74_313 VDD VSS sg13g2_decap_4
Xfanout175 _4827_/Q _4243_/B1 VDD VSS sg13g2_buf_1
Xfanout186 fanout188/X _4196_/B1 VDD VSS sg13g2_buf_1
Xfanout197 _4222_/A _4197_/S VDD VSS sg13g2_buf_1
XFILLER_28_730 VDD VSS sg13g2_decap_8
XFILLER_28_741 VDD VSS sg13g2_fill_2
XFILLER_74_346 VDD VSS sg13g2_fill_2
XFILLER_16_914 VDD VSS sg13g2_decap_8
XFILLER_16_925 VDD VSS sg13g2_fill_1
XFILLER_43_700 VDD VSS sg13g2_decap_8
XFILLER_90_828 VDD VSS sg13g2_fill_1
XFILLER_27_295 VDD VSS sg13g2_decap_4
XFILLER_55_582 VDD VSS sg13g2_decap_8
XFILLER_63_21 VDD VSS sg13g2_decap_8
XFILLER_15_457 VDD VSS sg13g2_decap_8
XFILLER_42_243 VDD VSS sg13g2_decap_8
XFILLER_70_541 VDD VSS sg13g2_decap_8
XFILLER_30_405 VDD VSS sg13g2_decap_8
XFILLER_43_788 VDD VSS sg13g2_decap_8
XFILLER_70_574 VDD VSS sg13g2_decap_8
Xclkbuf_leaf_22_clk clkbuf_4_6_0_clk/X _4964_/CLK VDD VSS sg13g2_buf_8
XFILLER_8_49 VDD VSS sg13g2_decap_8
XFILLER_7_612 VDD VSS sg13g2_decap_8
XFILLER_33_7 VDD VSS sg13g2_decap_8
XFILLER_3_884 VDD VSS sg13g2_decap_8
XFILLER_97_427 VDD VSS sg13g2_decap_8
XFILLER_66_803 VDD VSS sg13g2_decap_8
XFILLER_77_173 VDD VSS sg13g2_decap_8
XFILLER_92_110 VDD VSS sg13g2_decap_8
XFILLER_19_774 VDD VSS sg13g2_decap_8
XFILLER_19_785 VDD VSS sg13g2_fill_1
XFILLER_34_744 VDD VSS sg13g2_decap_4
XFILLER_74_880 VDD VSS sg13g2_fill_1
XFILLER_92_187 VDD VSS sg13g2_decap_8
XFILLER_61_541 VDD VSS sg13g2_decap_8
X_4821_ fanout313/X VSS VDD _4821_/D _4821_/Q _4824_/CLK sg13g2_dfrbpq_1
Xclkbuf_leaf_13_clk clkbuf_4_5_0_clk/X _4954_/CLK VDD VSS sg13g2_buf_8
X_4752_ fanout271/X VSS VDD _4752_/D _4752_/Q _4841_/CLK sg13g2_dfrbpq_1
X_4683_ fanout252/X VSS VDD _4683_/D _4683_/Q clkload3/A sg13g2_dfrbpq_1
X_3703_ _3726_/B _3703_/B _3703_/C _3703_/Y VDD VSS sg13g2_nor3_1
X_3634_ VSS VDD _3688_/A _3627_/Y _4738_/D _3633_/Y sg13g2_a21oi_1
X_3565_ _3565_/Y _3596_/B _4863_/Q VDD VSS sg13g2_nand2b_1
XFILLER_115_565 VDD VSS sg13g2_decap_4
X_3496_ _3496_/Y _3495_/Y _3424_/B _3494_/Y _3495_/B VDD VSS sg13g2_a22oi_1
X_2516_ _4578_/Q _4579_/Q _2516_/C _3186_/B _2516_/Y VDD VSS sg13g2_nor4_1
XFILLER_103_738 VDD VSS sg13g2_decap_8
XFILLER_115_598 VDD VSS sg13g2_decap_8
X_2447_ _3717_/A _3722_/A _3718_/A _2448_/B VDD VSS sg13g2_nor3_1
XFILLER_29_516 VDD VSS sg13g2_decap_8
X_2378_ _2388_/B _4678_/Q _4670_/Q VDD VSS sg13g2_xnor2_1
XFILLER_111_793 VDD VSS sg13g2_decap_8
XFILLER_56_324 VDD VSS sg13g2_fill_1
XFILLER_57_858 VDD VSS sg13g2_decap_8
XFILLER_68_195 VDD VSS sg13g2_decap_8
X_4117_ _4196_/B1 VDD _4117_/Y VSS _4196_/A1 _4346_/Q sg13g2_o21ai_1
XFILLER_44_519 VDD VSS sg13g2_decap_8
XFILLER_84_666 VDD VSS sg13g2_decap_8
X_4048_ _4265_/Q _4290_/Q _4052_/A _4048_/X VDD VSS sg13g2_mux2_1
XFILLER_17_58 VDD VSS sg13g2_fill_2
XFILLER_24_210 VDD VSS sg13g2_decap_8
XFILLER_25_733 VDD VSS sg13g2_decap_8
XFILLER_13_917 VDD VSS sg13g2_decap_8
XFILLER_80_894 VDD VSS sg13g2_decap_8
XFILLER_24_298 VDD VSS sg13g2_decap_8
XFILLER_106_587 VDD VSS sg13g2_decap_8
XFILLER_58_21 VDD VSS sg13g2_decap_4
XFILLER_79_449 VDD VSS sg13g2_decap_8
XFILLER_0_865 VDD VSS sg13g2_decap_8
XFILLER_58_54 VDD VSS sg13g2_decap_8
XFILLER_48_836 VDD VSS sg13g2_decap_8
XFILLER_59_151 VDD VSS sg13g2_decap_8
XFILLER_47_335 VDD VSS sg13g2_decap_8
XFILLER_75_633 VDD VSS sg13g2_fill_2
XFILLER_35_508 VDD VSS sg13g2_decap_8
XFILLER_63_817 VDD VSS sg13g2_decap_8
XFILLER_75_666 VDD VSS sg13g2_decap_8
XFILLER_28_571 VDD VSS sg13g2_decap_8
XFILLER_62_338 VDD VSS sg13g2_decap_8
XFILLER_74_64 VDD VSS sg13g2_decap_8
XFILLER_15_232 VDD VSS sg13g2_decap_8
XFILLER_70_360 VDD VSS sg13g2_decap_8
XFILLER_71_872 VDD VSS sg13g2_decap_4
XFILLER_90_41 VDD VSS sg13g2_decap_8
XFILLER_11_482 VDD VSS sg13g2_decap_8
XFILLER_7_431 VDD VSS sg13g2_decap_8
XFILLER_7_442 VDD VSS sg13g2_fill_2
XFILLER_99_61 VDD VSS sg13g2_decap_4
X_3350_ _3362_/A _3350_/B _3350_/C _4634_/D VDD VSS sg13g2_nor3_1
XFILLER_3_681 VDD VSS sg13g2_decap_8
X_2301_ VDD _2592_/B _3204_/A VSS sg13g2_inv_1
XFILLER_97_202 VDD VSS sg13g2_decap_8
XFILLER_85_408 VDD VSS sg13g2_decap_8
X_3281_ _3281_/A _3281_/B _4618_/D VDD VSS sg13g2_nor2_1
Xhold1109 _4358_/Q VDD VSS _2926_/A0 sg13g2_dlygate4sd3_1
Xclkbuf_leaf_2_clk clkbuf_4_1_0_clk/X clkload3/A VDD VSS sg13g2_buf_8
XFILLER_97_279 VDD VSS sg13g2_fill_2
XFILLER_94_920 VDD VSS sg13g2_decap_4
XFILLER_38_324 VDD VSS sg13g2_decap_8
XFILLER_78_482 VDD VSS sg13g2_decap_4
XFILLER_93_430 VDD VSS sg13g2_decap_8
XFILLER_66_666 VDD VSS sg13g2_decap_8
XFILLER_66_677 VDD VSS sg13g2_fill_2
XFILLER_93_474 VDD VSS sg13g2_fill_2
XFILLER_53_327 VDD VSS sg13g2_decap_8
XFILLER_22_703 VDD VSS sg13g2_decap_8
XFILLER_61_371 VDD VSS sg13g2_decap_8
XFILLER_62_872 VDD VSS sg13g2_decap_8
XFILLER_10_909 VDD VSS sg13g2_decap_8
XFILLER_21_213 VDD VSS sg13g2_decap_4
X_4804_ fanout290/X VSS VDD _4804_/D _4804_/Q _4807_/CLK sg13g2_dfrbpq_1
X_4735_ fanout284/X VSS VDD _4735_/D _4735_/Q _4737_/CLK sg13g2_dfrbpq_1
X_2996_ _2996_/A0 _3098_/A0 _3007_/S _4423_/D VDD VSS sg13g2_mux2_1
XFILLER_108_808 VDD VSS sg13g2_decap_8
XFILLER_30_780 VDD VSS sg13g2_decap_8
X_4666_ fanout254/X VSS VDD _4666_/D _4666_/Q clkload4/A sg13g2_dfrbpq_1
Xhold921 _4280_/Q VDD VSS hold921/X sg13g2_dlygate4sd3_1
Xhold910 _2889_/X VDD VSS _4322_/D sg13g2_dlygate4sd3_1
X_4597_ fanout290/X VSS VDD _4597_/D _4597_/Q _4601_/CLK sg13g2_dfrbpq_1
X_3617_ _3601_/B _3614_/A _3616_/Y _4729_/D VDD VSS sg13g2_a21o_1
XFILLER_116_852 VDD VSS sg13g2_decap_8
Xhold932 _4325_/Q VDD VSS hold932/X sg13g2_dlygate4sd3_1
Xhold943 _2881_/X VDD VSS _4314_/D sg13g2_dlygate4sd3_1
Xhold954 _4627_/Q VDD VSS hold954/X sg13g2_dlygate4sd3_1
X_3548_ _4710_/Q hold802/X _3550_/S _3548_/X VDD VSS sg13g2_mux2_1
XFILLER_1_618 VDD VSS sg13g2_decap_8
Xhold965 _2948_/X VDD VSS _4378_/D sg13g2_dlygate4sd3_1
Xhold976 _2821_/X VDD VSS _4260_/D sg13g2_dlygate4sd3_1
Xhold987 _4279_/Q VDD VSS hold987/X sg13g2_dlygate4sd3_1
Xhold998 _3016_/X VDD VSS _4442_/D sg13g2_dlygate4sd3_1
XFILLER_76_408 VDD VSS sg13g2_fill_2
X_3479_ _3483_/B _3481_/C _3479_/A _3479_/Y VDD VSS sg13g2_nand3_1
XFILLER_88_235 VDD VSS sg13g2_decap_8
Xhold1610 _3222_/B VDD VSS _3220_/A sg13g2_dlygate4sd3_1
XFILLER_85_920 VDD VSS sg13g2_decap_4
XFILLER_111_590 VDD VSS sg13g2_decap_8
XFILLER_29_324 VDD VSS sg13g2_decap_8
XFILLER_57_655 VDD VSS sg13g2_decap_8
XFILLER_69_482 VDD VSS sg13g2_decap_8
Xhold1621 _3843_/Y VDD VSS _4788_/D sg13g2_dlygate4sd3_1
Xhold1632 _4911_/Q VDD VSS _2407_/C sg13g2_dlygate4sd3_1
Xhold1643 _3822_/Y VDD VSS _4781_/D sg13g2_dlygate4sd3_1
XFILLER_17_508 VDD VSS sg13g2_decap_8
XFILLER_28_79 VDD VSS sg13g2_decap_8
XFILLER_45_828 VDD VSS sg13g2_fill_2
XFILLER_56_154 VDD VSS sg13g2_decap_8
XFILLER_84_452 VDD VSS sg13g2_decap_8
Xhold1654 _3422_/X VDD VSS _4648_/D sg13g2_dlygate4sd3_1
Xhold1665 _4899_/Q VDD VSS _2622_/B sg13g2_dlygate4sd3_1
Xhold1676 _4725_/Q VDD VSS _2701_/B sg13g2_dlygate4sd3_1
XFILLER_71_124 VDD VSS sg13g2_fill_2
XFILLER_84_485 VDD VSS sg13g2_decap_8
XFILLER_12_202 VDD VSS sg13g2_fill_1
XFILLER_25_596 VDD VSS sg13g2_decap_8
XFILLER_40_555 VDD VSS sg13g2_decap_8
XFILLER_4_423 VDD VSS sg13g2_decap_8
XFILLER_107_0 VDD VSS sg13g2_decap_8
XFILLER_107_874 VDD VSS sg13g2_decap_8
XFILLER_109_71 VDD VSS sg13g2_decap_8
XFILLER_4_478 VDD VSS sg13g2_fill_2
XFILLER_79_202 VDD VSS sg13g2_decap_8
XFILLER_0_662 VDD VSS sg13g2_decap_8
XFILLER_67_419 VDD VSS sg13g2_decap_8
XFILLER_76_920 VDD VSS sg13g2_decap_4
XFILLER_95_728 VDD VSS sg13g2_decap_8
XFILLER_94_249 VDD VSS sg13g2_decap_8
XFILLER_85_52 VDD VSS sg13g2_decap_8
XFILLER_75_441 VDD VSS sg13g2_decap_8
XFILLER_75_496 VDD VSS sg13g2_decap_8
XFILLER_90_455 VDD VSS sg13g2_fill_1
XFILLER_16_574 VDD VSS sg13g2_fill_1
XFILLER_62_168 VDD VSS sg13g2_decap_8
XFILLER_90_488 VDD VSS sg13g2_decap_8
XFILLER_31_522 VDD VSS sg13g2_decap_8
X_2850_ _4796_/Q _4795_/Q _3009_/A _2850_/Y VDD VSS sg13g2_nor3_1
X_2781_ _2782_/B _3528_/A _2783_/B VDD VSS sg13g2_nand2_1
X_4520_ fanout312/X VSS VDD _4520_/D _4520_/Q _4973_/CLK sg13g2_dfrbpq_1
XFILLER_116_126 VDD VSS sg13g2_decap_8
X_4451_ _4451_/RESET_B VSS VDD _4451_/D _4451_/Q _4979_/CLK sg13g2_dfrbpq_1
X_3402_ _3413_/C _3413_/D _3402_/C _3402_/Y VDD VSS sg13g2_nor3_1
XFILLER_113_811 VDD VSS sg13g2_fill_2
X_4382_ _4382_/RESET_B VSS VDD _4382_/D _4382_/Q _4959_/CLK sg13g2_dfrbpq_1
XFILLER_98_511 VDD VSS sg13g2_decap_8
X_3333_ _3405_/B VDD _3489_/C VSS _3331_/Y _3332_/Y sg13g2_o21ai_1
XFILLER_86_706 VDD VSS sg13g2_decap_8
XFILLER_22_0 VDD VSS sg13g2_decap_8
XFILLER_58_419 VDD VSS sg13g2_fill_1
X_3264_ _3281_/A _3264_/B _4611_/D VDD VSS sg13g2_nor2_1
XFILLER_98_577 VDD VSS sg13g2_decap_8
XFILLER_100_538 VDD VSS sg13g2_decap_8
XFILLER_66_441 VDD VSS sg13g2_decap_8
X_3195_ _3195_/B _3195_/A _3195_/X VDD VSS sg13g2_xor2_1
XFILLER_94_772 VDD VSS sg13g2_decap_8
XFILLER_93_293 VDD VSS sg13g2_decap_4
XFILLER_35_861 VDD VSS sg13g2_decap_8
XFILLER_34_382 VDD VSS sg13g2_fill_2
XFILLER_22_566 VDD VSS sg13g2_decap_8
XFILLER_50_864 VDD VSS sg13g2_decap_8
X_2979_ _2979_/A0 _3032_/A1 _2979_/S _2979_/X VDD VSS sg13g2_mux2_1
XFILLER_30_14 VDD VSS sg13g2_decap_8
X_4718_ fanout332/X VSS VDD _4718_/D _4718_/Q _4933_/CLK sg13g2_dfrbpq_1
X_4649_ fanout252/X VSS VDD _4649_/D _4649_/Q clkload3/A sg13g2_dfrbpq_1
XFILLER_100_7 VDD VSS sg13g2_decap_8
XFILLER_30_69 VDD VSS sg13g2_decap_8
XFILLER_1_415 VDD VSS sg13g2_decap_8
Xhold773 _3284_/Y VDD VSS _4619_/D sg13g2_dlygate4sd3_1
Xhold762 _3161_/Y VDD VSS _4567_/D sg13g2_dlygate4sd3_1
Xhold751 _2769_/Y VDD VSS _4936_/D sg13g2_dlygate4sd3_1
Xhold740 _4952_/Q VDD VSS _2748_/B sg13g2_dlygate4sd3_1
Xhold795 _4529_/Q VDD VSS hold795/X sg13g2_dlygate4sd3_1
Xhold784 _4480_/Q VDD VSS hold784/X sg13g2_dlygate4sd3_1
XFILLER_76_216 VDD VSS sg13g2_decap_8
XFILLER_103_387 VDD VSS sg13g2_decap_8
XFILLER_39_78 VDD VSS sg13g2_decap_8
XFILLER_76_249 VDD VSS sg13g2_decap_8
XFILLER_57_452 VDD VSS sg13g2_decap_4
Xhold1440 _2425_/Y VDD VSS _2426_/B sg13g2_dlygate4sd3_1
Xhold1451 _4747_/Q VDD VSS _3652_/A0 sg13g2_dlygate4sd3_1
XFILLER_45_614 VDD VSS sg13g2_decap_4
XFILLER_84_282 VDD VSS sg13g2_decap_4
Xhold1462 _4742_/Q VDD VSS _3645_/A0 sg13g2_dlygate4sd3_1
Xhold1473 _3750_/Y VDD VSS _4763_/D sg13g2_dlygate4sd3_1
Xhold1484 _3280_/X VDD VSS _3281_/B sg13g2_dlygate4sd3_1
Xhold1495 _4842_/Q VDD VSS _2721_/B sg13g2_dlygate4sd3_1
XFILLER_44_124 VDD VSS sg13g2_decap_8
XFILLER_44_157 VDD VSS sg13g2_decap_8
XFILLER_60_617 VDD VSS sg13g2_fill_1
XFILLER_111_72 VDD VSS sg13g2_fill_1
XFILLER_13_522 VDD VSS sg13g2_decap_8
XFILLER_25_393 VDD VSS sg13g2_decap_8
XFILLER_40_341 VDD VSS sg13g2_decap_8
XFILLER_13_599 VDD VSS sg13g2_decap_8
XFILLER_9_537 VDD VSS sg13g2_decap_8
XFILLER_5_732 VDD VSS sg13g2_decap_8
XFILLER_4_275 VDD VSS sg13g2_decap_8
XFILLER_110_847 VDD VSS sg13g2_decap_8
XFILLER_49_920 VDD VSS sg13g2_decap_4
XFILLER_67_227 VDD VSS sg13g2_decap_8
XFILLER_48_441 VDD VSS sg13g2_decap_8
XFILLER_76_794 VDD VSS sg13g2_decap_8
XFILLER_36_669 VDD VSS sg13g2_decap_8
XFILLER_63_444 VDD VSS sg13g2_decap_8
XFILLER_75_293 VDD VSS sg13g2_decap_8
XFILLER_91_764 VDD VSS sg13g2_decap_8
XFILLER_90_241 VDD VSS sg13g2_decap_8
XFILLER_16_360 VDD VSS sg13g2_decap_8
X_3951_ _3954_/D _3951_/B _3951_/Y VDD VSS sg13g2_nor2_1
XFILLER_32_842 VDD VSS sg13g2_fill_2
XFILLER_44_680 VDD VSS sg13g2_decap_8
XFILLER_50_138 VDD VSS sg13g2_decap_8
X_2902_ _2902_/A0 _3110_/A0 _2902_/S _2902_/X VDD VSS sg13g2_mux2_1
XFILLER_31_330 VDD VSS sg13g2_decap_8
XFILLER_32_853 VDD VSS sg13g2_decap_8
XFILLER_32_864 VDD VSS sg13g2_fill_1
X_3882_ _3882_/Y _3886_/B _3911_/B VDD VSS sg13g2_nand2_1
X_2833_ _2833_/A0 _3095_/A0 _2842_/S _2833_/X VDD VSS sg13g2_mux2_1
X_2764_ _2766_/B _2784_/A _2764_/Y VDD VSS sg13g2_nor2_1
X_4503_ fanout312/X VSS VDD _4503_/D _4503_/Q _4527_/CLK sg13g2_dfrbpq_1
XFILLER_8_570 VDD VSS sg13g2_decap_8
X_2695_ _3506_/A _2698_/B _2695_/C _2696_/C VDD VSS sg13g2_or3_1
XFILLER_6_71 VDD VSS sg13g2_decap_8
X_4434_ _4434_/RESET_B VSS VDD _4434_/D _4434_/Q _4967_/CLK sg13g2_dfrbpq_1
XFILLER_116_28 VDD VSS sg13g2_decap_8
X_4365_ _4365_/RESET_B VSS VDD _4365_/D _4365_/Q _4964_/CLK sg13g2_dfrbpq_1
XFILLER_113_652 VDD VSS sg13g2_decap_8
X_3316_ VSS VDD _3316_/X _4781_/Q _4780_/Q sg13g2_or2_1
XFILLER_100_313 VDD VSS sg13g2_decap_8
XFILLER_101_858 VDD VSS sg13g2_decap_8
XFILLER_58_227 VDD VSS sg13g2_decap_8
X_4296_ _4296_/RESET_B VSS VDD _4296_/D _4296_/Q _4973_/CLK sg13g2_dfrbpq_1
X_3247_ _4006_/A _3249_/B _3247_/Y VDD VSS sg13g2_nor2_1
XFILLER_26_102 VDD VSS sg13g2_decap_8
XFILLER_27_603 VDD VSS sg13g2_decap_8
XFILLER_54_411 VDD VSS sg13g2_decap_8
XFILLER_66_260 VDD VSS sg13g2_fill_1
XFILLER_67_772 VDD VSS sg13g2_decap_8
XFILLER_73_219 VDD VSS sg13g2_decap_8
X_3178_ _2512_/B VDD _3178_/Y VSS _3176_/A _3176_/B sg13g2_o21ai_1
XFILLER_82_753 VDD VSS sg13g2_decap_8
XFILLER_25_14 VDD VSS sg13g2_decap_8
XFILLER_26_168 VDD VSS sg13g2_decap_8
XFILLER_54_488 VDD VSS sg13g2_decap_8
XFILLER_41_116 VDD VSS sg13g2_decap_8
XFILLER_41_127 VDD VSS sg13g2_fill_1
XFILLER_54_499 VDD VSS sg13g2_fill_1
XFILLER_41_149 VDD VSS sg13g2_decap_8
XFILLER_50_694 VDD VSS sg13g2_decap_8
XFILLER_108_424 VDD VSS sg13g2_fill_2
XFILLER_108_435 VDD VSS sg13g2_fill_2
XFILLER_2_757 VDD VSS sg13g2_decap_8
Xhold570 _4874_/Q VDD VSS _2541_/A sg13g2_dlygate4sd3_1
Xhold581 _2547_/Y VDD VSS _4877_/D sg13g2_dlygate4sd3_1
XFILLER_1_267 VDD VSS sg13g2_decap_8
Xhold592 _2563_/Y VDD VSS _4884_/D sg13g2_dlygate4sd3_1
XFILLER_89_352 VDD VSS sg13g2_decap_8
XFILLER_104_696 VDD VSS sg13g2_decap_8
XFILLER_66_21 VDD VSS sg13g2_decap_8
XFILLER_73_720 VDD VSS sg13g2_decap_4
Xhold1270 _4306_/Q VDD VSS _2871_/A0 sg13g2_dlygate4sd3_1
XFILLER_17_113 VDD VSS sg13g2_decap_8
XFILLER_66_98 VDD VSS sg13g2_decap_8
Xhold1281 _2767_/Y VDD VSS _4935_/D sg13g2_dlygate4sd3_1
Xhold1292 _4339_/Q VDD VSS _2907_/A0 sg13g2_dlygate4sd3_1
XFILLER_82_75 VDD VSS sg13g2_fill_1
XFILLER_13_341 VDD VSS sg13g2_decap_8
XFILLER_9_301 VDD VSS sg13g2_decap_8
XFILLER_14_886 VDD VSS sg13g2_decap_8
XFILLER_15_80 VDD VSS sg13g2_decap_8
XFILLER_40_160 VDD VSS sg13g2_decap_8
XFILLER_9_378 VDD VSS sg13g2_decap_8
XFILLER_63_7 VDD VSS sg13g2_decap_8
X_4397__529 VDD VSS _4397_/RESET_B sg13g2_tiehi
X_2480_ _2481_/C _3955_/A _2480_/B VDD VSS sg13g2_nand2_1
X_4150_ _4375_/Q _4400_/Q _4233_/S _4150_/X VDD VSS sg13g2_mux2_1
XFILLER_96_812 VDD VSS sg13g2_decap_8
X_3101_ _3101_/A0 hold874/X _3104_/S _4525_/D VDD VSS sg13g2_mux2_1
XFILLER_96_856 VDD VSS sg13g2_decap_8
XFILLER_37_901 VDD VSS sg13g2_decap_8
X_4081_ _4144_/S _4268_/Q _4293_/Q _4318_/Q _4343_/Q _4232_/B1 _4081_/X VDD VSS sg13g2_mux4_1
XFILLER_49_794 VDD VSS sg13g2_fill_2
XFILLER_83_528 VDD VSS sg13g2_fill_1
X_3032_ hold977/X _3032_/A1 _3033_/S _3032_/X VDD VSS sg13g2_mux2_1
XFILLER_95_388 VDD VSS sg13g2_fill_1
XFILLER_48_293 VDD VSS sg13g2_decap_8
XFILLER_64_753 VDD VSS sg13g2_decap_8
XFILLER_91_561 VDD VSS sg13g2_decap_8
XFILLER_51_425 VDD VSS sg13g2_fill_1
X_3934_ VSS VDD _3935_/A _3932_/A _3934_/Y _3933_/Y sg13g2_a21oi_1
X_3865_ _3866_/A _3866_/B _3866_/C _3953_/A VDD VSS sg13g2_nor3_1
XFILLER_20_856 VDD VSS sg13g2_decap_8
X_2816_ _2816_/A _2815_/Y _4923_/D VDD VSS sg13g2_nor2b_1
X_3796_ _4763_/Q _3796_/B _4761_/Q _3817_/B _3826_/B VDD VSS sg13g2_nor4_1
X_2747_ VSS VDD _4951_/Q _2748_/C _2747_/Y _2748_/B sg13g2_a21oi_1
XFILLER_105_427 VDD VSS sg13g2_decap_4
X_2678_ _2678_/B _2678_/C _2678_/A _2678_/Y VDD VSS sg13g2_nand3_1
XFILLER_105_438 VDD VSS sg13g2_fill_1
X_4417_ _4417_/RESET_B VSS VDD _4417_/D _4417_/Q _4527_/CLK sg13g2_dfrbpq_1
Xfanout302 fanout305/X fanout302/X VDD VSS sg13g2_buf_1
Xfanout313 fanout314/X fanout313/X VDD VSS sg13g2_buf_1
Xfanout324 fanout336/X fanout324/X VDD VSS sg13g2_buf_1
Xfanout335 fanout336/X fanout335/X VDD VSS sg13g2_buf_1
X_4348_ _4348_/RESET_B VSS VDD _4348_/D _4348_/Q _4967_/CLK sg13g2_dfrbpq_1
XFILLER_87_856 VDD VSS sg13g2_decap_8
X_4279_ _4279_/RESET_B VSS VDD _4279_/D _4279_/Q _4552_/CLK sg13g2_dfrbpq_1
XFILLER_98_193 VDD VSS sg13g2_fill_2
XFILLER_86_344 VDD VSS sg13g2_fill_1
XFILLER_100_165 VDD VSS sg13g2_decap_8
XFILLER_101_699 VDD VSS sg13g2_decap_8
XFILLER_39_260 VDD VSS sg13g2_decap_8
XFILLER_55_742 VDD VSS sg13g2_decap_8
XFILLER_36_57 VDD VSS sg13g2_decap_8
XFILLER_14_105 VDD VSS sg13g2_fill_1
XFILLER_54_285 VDD VSS sg13g2_decap_8
XFILLER_70_723 VDD VSS sg13g2_decap_8
XFILLER_70_745 VDD VSS sg13g2_decap_8
XFILLER_14_149 VDD VSS sg13g2_fill_1
XFILLER_11_823 VDD VSS sg13g2_decap_8
XFILLER_52_56 VDD VSS sg13g2_decap_8
XFILLER_109_700 VDD VSS sg13g2_decap_8
XFILLER_22_171 VDD VSS sg13g2_decap_8
XFILLER_52_67 VDD VSS sg13g2_fill_2
XFILLER_10_388 VDD VSS sg13g2_decap_8
XFILLER_108_265 VDD VSS sg13g2_decap_4
XFILLER_97_609 VDD VSS sg13g2_decap_8
XFILLER_104_471 VDD VSS sg13g2_decap_8
XFILLER_77_322 VDD VSS sg13g2_decap_4
XFILLER_78_834 VDD VSS sg13g2_decap_8
XFILLER_93_815 VDD VSS sg13g2_decap_8
XFILLER_65_528 VDD VSS sg13g2_decap_8
XFILLER_77_366 VDD VSS sg13g2_decap_8
XFILLER_61_712 VDD VSS sg13g2_fill_1
XFILLER_73_572 VDD VSS sg13g2_decap_4
XFILLER_93_74 VDD VSS sg13g2_decap_8
XFILLER_92_369 VDD VSS sg13g2_decap_8
XFILLER_60_200 VDD VSS sg13g2_decap_4
XFILLER_60_233 VDD VSS sg13g2_fill_1
XFILLER_14_661 VDD VSS sg13g2_fill_2
XFILLER_14_672 VDD VSS sg13g2_decap_8
XFILLER_41_480 VDD VSS sg13g2_decap_8
XFILLER_41_491 VDD VSS sg13g2_fill_2
X_3650_ _3649_/Y VDD _4745_/D VSS _3712_/C _3652_/S sg13g2_o21ai_1
X_3581_ _3581_/A _3581_/B _3581_/Y VDD VSS sg13g2_nor2_1
X_2601_ _4595_/Q _4596_/Q _3224_/B _2601_/D _3234_/B VDD VSS sg13g2_or4_1
XFILLER_9_186 VDD VSS sg13g2_fill_1
XFILLER_6_882 VDD VSS sg13g2_decap_8
X_2532_ VSS VDD _2528_/Y _2530_/Y _3807_/B _2531_/Y sg13g2_a21oi_1
XFILLER_115_747 VDD VSS sg13g2_decap_8
XFILLER_114_268 VDD VSS sg13g2_decap_8
X_4202_ _4201_/Y VDD _4202_/Y VSS _4199_/Y _4200_/Y sg13g2_o21ai_1
X_2463_ _4943_/Q _4944_/Q _4945_/Q _4946_/Q _2464_/D VDD VSS sg13g2_nor4_1
XFILLER_114_279 VDD VSS sg13g2_fill_2
XFILLER_69_845 VDD VSS sg13g2_decap_8
X_2394_ VSS VDD _2432_/C _4913_/Q _2433_/A sg13g2_or2_1
XFILLER_68_355 VDD VSS sg13g2_fill_1
XFILLER_69_889 VDD VSS sg13g2_decap_8
X_4133_ _4240_/A _4423_/Q _4133_/Y VDD VSS sg13g2_nor2_1
XFILLER_96_642 VDD VSS sg13g2_decap_8
XFILLER_95_141 VDD VSS sg13g2_fill_1
XFILLER_56_517 VDD VSS sg13g2_decap_8
XFILLER_68_388 VDD VSS sg13g2_decap_8
XFILLER_83_314 VDD VSS sg13g2_decap_8
XFILLER_84_815 VDD VSS sg13g2_decap_8
X_4064_ VSS VDD _4244_/A1 _4062_/X _4064_/Y _4063_/Y sg13g2_a21oi_1
XFILLER_96_697 VDD VSS sg13g2_decap_8
XFILLER_110_496 VDD VSS sg13g2_decap_8
XFILLER_49_591 VDD VSS sg13g2_decap_8
X_3015_ _3015_/A0 _4515_/Q _3029_/S _3015_/X VDD VSS sg13g2_mux2_1
XFILLER_25_915 VDD VSS sg13g2_decap_8
XFILLER_71_509 VDD VSS sg13g2_fill_1
XFILLER_36_263 VDD VSS sg13g2_fill_1
XFILLER_64_583 VDD VSS sg13g2_decap_8
XFILLER_92_881 VDD VSS sg13g2_decap_8
XFILLER_51_233 VDD VSS sg13g2_decap_4
XFILLER_51_288 VDD VSS sg13g2_decap_4
X_4966_ fanout297/X VSS VDD _4966_/D _4966_/Q _4966_/CLK sg13g2_dfrbpq_1
X_4897_ fanout257/X VSS VDD _4897_/D _4897_/Q _4907_/CLK sg13g2_dfrbpq_1
X_3917_ _3915_/Y VDD _3917_/Y VSS _3919_/A _3916_/Y sg13g2_o21ai_1
X_3848_ _3848_/Y _3848_/A _3848_/B VDD VSS sg13g2_nand2_1
XFILLER_20_697 VDD VSS sg13g2_decap_8
X_3779_ _3844_/A _3779_/C _3847_/A _3786_/C VDD VSS sg13g2_nand3_1
XFILLER_106_747 VDD VSS sg13g2_fill_2
Xfanout110 fanout113/X _2847_/S VDD VSS sg13g2_buf_1
Xfanout121 _3654_/S _3653_/S VDD VSS sg13g2_buf_1
XFILLER_101_441 VDD VSS sg13g2_decap_4
Xfanout132 _4188_/B1 _4244_/A1 VDD VSS sg13g2_buf_1
Xfanout143 _3192_/A _2645_/A VDD VSS sg13g2_buf_1
Xfanout154 _3058_/S _3051_/S VDD VSS sg13g2_buf_1
Xfanout165 _4848_/Q fanout165/X VDD VSS sg13g2_buf_1
XFILLER_87_642 VDD VSS sg13g2_fill_1
XFILLER_86_130 VDD VSS sg13g2_decap_8
XFILLER_75_837 VDD VSS sg13g2_decap_4
Xfanout176 _4254_/A1 _4218_/A1 VDD VSS sg13g2_buf_1
Xfanout187 fanout188/X _4190_/A1 VDD VSS sg13g2_buf_1
Xfanout198 _4222_/A _4118_/S VDD VSS sg13g2_buf_1
XFILLER_47_78 VDD VSS sg13g2_decap_4
XFILLER_75_848 VDD VSS sg13g2_decap_8
XFILLER_103_73 VDD VSS sg13g2_decap_8
XFILLER_103_84 VDD VSS sg13g2_fill_2
XFILLER_15_436 VDD VSS sg13g2_decap_8
XFILLER_27_274 VDD VSS sg13g2_decap_8
XFILLER_42_211 VDD VSS sg13g2_fill_1
XFILLER_70_520 VDD VSS sg13g2_decap_4
XFILLER_43_756 VDD VSS sg13g2_fill_1
XFILLER_43_767 VDD VSS sg13g2_decap_8
XFILLER_10_185 VDD VSS sg13g2_fill_2
XFILLER_11_686 VDD VSS sg13g2_decap_8
XFILLER_6_134 VDD VSS sg13g2_decap_8
XFILLER_109_563 VDD VSS sg13g2_fill_2
XFILLER_12_81 VDD VSS sg13g2_decap_8
XFILLER_7_668 VDD VSS sg13g2_decap_8
XFILLER_7_679 VDD VSS sg13g2_fill_2
XFILLER_3_863 VDD VSS sg13g2_decap_8
XFILLER_97_406 VDD VSS sg13g2_decap_8
XFILLER_88_52 VDD VSS sg13g2_decap_8
XFILLER_2_362 VDD VSS sg13g2_decap_8
XFILLER_26_7 VDD VSS sg13g2_decap_8
XFILLER_78_653 VDD VSS sg13g2_decap_8
XFILLER_77_152 VDD VSS sg13g2_decap_8
XFILLER_65_325 VDD VSS sg13g2_fill_1
XFILLER_18_252 VDD VSS sg13g2_decap_8
XFILLER_19_753 VDD VSS sg13g2_decap_8
XFILLER_80_306 VDD VSS sg13g2_fill_2
XFILLER_92_166 VDD VSS sg13g2_decap_8
XFILLER_34_723 VDD VSS sg13g2_decap_8
XFILLER_80_317 VDD VSS sg13g2_fill_1
X_4820_ fanout313/X VSS VDD _4820_/D _4820_/Q _4824_/CLK sg13g2_dfrbpq_1
XFILLER_21_417 VDD VSS sg13g2_fill_1
X_4751_ fanout270/X VSS VDD _4751_/D _4751_/Q _4942_/CLK sg13g2_dfrbpq_1
X_4682_ fanout253/X VSS VDD _4682_/D _4682_/Q clkload2/A sg13g2_dfrbpq_1
X_3702_ VSS VDD _3690_/A _3690_/B _3703_/C _3701_/Y sg13g2_a21oi_1
X_3633_ _3688_/A _3633_/B _3633_/Y VDD VSS sg13g2_nor2_1
XFILLER_52_0 VDD VSS sg13g2_decap_8
XFILLER_6_690 VDD VSS sg13g2_fill_1
X_3564_ _3561_/Y VDD _3564_/Y VSS _3562_/Y _3563_/Y sg13g2_o21ai_1
XFILLER_115_544 VDD VSS sg13g2_decap_8
XFILLER_115_577 VDD VSS sg13g2_decap_8
X_3495_ _3495_/Y _3495_/A _3495_/B VDD VSS sg13g2_nand2_1
X_2515_ _4578_/Q _2515_/B _3186_/B _3189_/A VDD VSS sg13g2_nor3_1
X_2446_ VSS VDD _2705_/A _2356_/Y _4859_/D _4932_/D sg13g2_a21oi_1
X_4116_ _4118_/S _4321_/Q _4116_/Y VDD VSS sg13g2_nor2_1
X_2377_ _2365_/Y VDD _2386_/B VSS _4676_/Q _4668_/Q sg13g2_o21ai_1
XFILLER_68_174 VDD VSS sg13g2_decap_8
XFILLER_84_645 VDD VSS sg13g2_decap_8
XFILLER_96_494 VDD VSS sg13g2_decap_4
XFILLER_84_689 VDD VSS sg13g2_fill_1
X_4047_ _4226_/S1 VDD _4047_/Y VSS _4250_/A1 hold939/X sg13g2_o21ai_1
XFILLER_37_583 VDD VSS sg13g2_decap_8
XFILLER_71_339 VDD VSS sg13g2_decap_8
XFILLER_83_177 VDD VSS sg13g2_decap_8
XFILLER_80_862 VDD VSS sg13g2_decap_8
XFILLER_33_14 VDD VSS sg13g2_decap_8
XFILLER_40_737 VDD VSS sg13g2_fill_2
XFILLER_80_884 VDD VSS sg13g2_fill_1
X_4949_ fanout276/X VSS VDD _4949_/D _4949_/Q _4954_/CLK sg13g2_dfrbpq_1
XFILLER_33_69 VDD VSS sg13g2_decap_8
XFILLER_4_616 VDD VSS sg13g2_decap_4
XFILLER_106_566 VDD VSS sg13g2_decap_8
XFILLER_79_428 VDD VSS sg13g2_decap_8
XFILLER_0_844 VDD VSS sg13g2_decap_8
XFILLER_58_33 VDD VSS sg13g2_decap_8
XFILLER_48_815 VDD VSS sg13g2_decap_8
XFILLER_114_50 VDD VSS sg13g2_decap_8
XFILLER_47_314 VDD VSS sg13g2_decap_8
XFILLER_75_645 VDD VSS sg13g2_decap_8
XFILLER_28_550 VDD VSS sg13g2_decap_8
XFILLER_74_144 VDD VSS sg13g2_decap_8
XFILLER_62_317 VDD VSS sg13g2_decap_8
XFILLER_74_177 VDD VSS sg13g2_decap_8
XFILLER_90_626 VDD VSS sg13g2_fill_1
XFILLER_16_756 VDD VSS sg13g2_decap_8
XFILLER_71_851 VDD VSS sg13g2_decap_8
XFILLER_15_266 VDD VSS sg13g2_fill_1
XFILLER_15_299 VDD VSS sg13g2_decap_4
XFILLER_30_236 VDD VSS sg13g2_decap_8
XFILLER_30_247 VDD VSS sg13g2_fill_1
XFILLER_30_258 VDD VSS sg13g2_decap_8
XFILLER_8_911 VDD VSS sg13g2_decap_8
XFILLER_11_461 VDD VSS sg13g2_decap_8
XFILLER_7_410 VDD VSS sg13g2_decap_8
X_3280_ _3280_/B _3280_/A _3280_/X VDD VSS sg13g2_xor2_1
X_2300_ VDD _2592_/A _3202_/A VSS sg13g2_inv_1
XFILLER_98_748 VDD VSS sg13g2_decap_8
XFILLER_112_558 VDD VSS sg13g2_decap_4
XFILLER_2_181 VDD VSS sg13g2_decap_4
XFILLER_97_258 VDD VSS sg13g2_decap_8
XFILLER_38_303 VDD VSS sg13g2_decap_8
XFILLER_78_461 VDD VSS sg13g2_decap_8
XFILLER_66_645 VDD VSS sg13g2_decap_8
XFILLER_26_509 VDD VSS sg13g2_decap_8
XFILLER_53_306 VDD VSS sg13g2_decap_8
XFILLER_65_144 VDD VSS sg13g2_decap_8
XFILLER_65_155 VDD VSS sg13g2_decap_8
XFILLER_0_84 VDD VSS sg13g2_decap_8
XFILLER_62_851 VDD VSS sg13g2_decap_8
XFILLER_61_350 VDD VSS sg13g2_decap_8
XFILLER_62_895 VDD VSS sg13g2_fill_1
XFILLER_22_759 VDD VSS sg13g2_decap_8
X_4803_ fanout292/X VSS VDD _4803_/D _4803_/Q _4807_/CLK sg13g2_dfrbpq_1
XFILLER_21_247 VDD VSS sg13g2_decap_4
X_4734_ fanout284/X VSS VDD _4734_/D _4734_/Q _4737_/CLK sg13g2_dfrbpq_1
X_2995_ hold988/X _3021_/A1 _3003_/S _2995_/X VDD VSS sg13g2_mux2_1
X_4665_ fanout254/X VSS VDD _4665_/D _4665_/Q clkload4/A sg13g2_dfrbpq_1
XFILLER_116_831 VDD VSS sg13g2_decap_8
Xhold922 _4583_/Q VDD VSS _2589_/C sg13g2_dlygate4sd3_1
Xhold911 _4320_/Q VDD VSS hold911/X sg13g2_dlygate4sd3_1
Xhold900 _4333_/Q VDD VSS hold900/X sg13g2_dlygate4sd3_1
X_4596_ fanout289/X VSS VDD _4596_/D _4596_/Q _4807_/CLK sg13g2_dfrbpq_1
X_3616_ VSS VDD _3596_/B _3571_/A _3616_/Y _3615_/Y sg13g2_a21oi_1
Xhold933 _2892_/X VDD VSS _4325_/D sg13g2_dlygate4sd3_1
Xhold944 _4284_/Q VDD VSS hold944/X sg13g2_dlygate4sd3_1
Xhold955 _4291_/Q VDD VSS hold955/X sg13g2_dlygate4sd3_1
X_3547_ _4709_/Q _3547_/A1 _3550_/S _3547_/X VDD VSS sg13g2_mux2_1
XFILLER_115_385 VDD VSS sg13g2_decap_8
Xhold966 _4711_/Q VDD VSS hold966/X sg13g2_dlygate4sd3_1
Xhold977 _4458_/Q VDD VSS hold977/X sg13g2_dlygate4sd3_1
Xhold988 _4422_/Q VDD VSS hold988/X sg13g2_dlygate4sd3_1
XFILLER_88_214 VDD VSS sg13g2_decap_8
Xhold999 _4507_/Q VDD VSS hold999/X sg13g2_dlygate4sd3_1
X_3478_ _3477_/Y VDD _3478_/Y VSS _2279_/Y _3477_/C sg13g2_o21ai_1
XFILLER_29_303 VDD VSS sg13g2_decap_8
Xhold1600 _4565_/Q VDD VSS _3156_/A sg13g2_dlygate4sd3_1
X_2429_ _3407_/A _2429_/B _2800_/B VDD VSS sg13g2_nor2_1
XFILLER_57_634 VDD VSS sg13g2_decap_8
XFILLER_84_431 VDD VSS sg13g2_decap_8
Xhold1611 _4599_/Q VDD VSS _3234_/A sg13g2_dlygate4sd3_1
Xhold1622 _4578_/Q VDD VSS _3186_/A sg13g2_dlygate4sd3_1
Xhold1633 _4602_/Q VDD VSS _3244_/A sg13g2_dlygate4sd3_1
Xhold1644 _4575_/Q VDD VSS _2512_/B sg13g2_dlygate4sd3_1
XFILLER_28_58 VDD VSS sg13g2_decap_8
XFILLER_45_807 VDD VSS sg13g2_decap_8
XFILLER_56_133 VDD VSS sg13g2_decap_8
Xhold1655 _4596_/Q VDD VSS _2598_/B sg13g2_dlygate4sd3_1
Xhold1666 _4784_/Q VDD VSS _2315_/A sg13g2_dlygate4sd3_1
Xhold1677 _3603_/C VDD VSS _3602_/B sg13g2_dlygate4sd3_1
XFILLER_38_870 VDD VSS sg13g2_decap_4
XFILLER_71_103 VDD VSS sg13g2_decap_8
XFILLER_72_615 VDD VSS sg13g2_decap_8
XFILLER_71_158 VDD VSS sg13g2_decap_8
XFILLER_13_704 VDD VSS sg13g2_decap_8
XFILLER_25_564 VDD VSS sg13g2_fill_1
XFILLER_53_862 VDD VSS sg13g2_decap_8
XFILLER_80_692 VDD VSS sg13g2_decap_4
XFILLER_100_96 VDD VSS sg13g2_fill_2
XFILLER_21_770 VDD VSS sg13g2_decap_8
XFILLER_5_914 VDD VSS sg13g2_decap_8
XFILLER_109_50 VDD VSS sg13g2_decap_8
XFILLER_5_925 VDD VSS sg13g2_fill_1
XFILLER_107_853 VDD VSS sg13g2_decap_8
XFILLER_5_29 VDD VSS sg13g2_decap_8
XFILLER_79_258 VDD VSS sg13g2_decap_8
XFILLER_95_707 VDD VSS sg13g2_decap_8
XFILLER_0_641 VDD VSS sg13g2_decap_8
XFILLER_48_601 VDD VSS sg13g2_fill_2
XFILLER_48_634 VDD VSS sg13g2_decap_8
XFILLER_87_291 VDD VSS sg13g2_decap_8
XFILLER_47_166 VDD VSS sg13g2_decap_8
XFILLER_47_177 VDD VSS sg13g2_fill_1
XFILLER_48_689 VDD VSS sg13g2_decap_4
XFILLER_63_615 VDD VSS sg13g2_decap_8
XFILLER_75_486 VDD VSS sg13g2_fill_1
XFILLER_85_97 VDD VSS sg13g2_decap_4
XFILLER_16_531 VDD VSS sg13g2_decap_8
XFILLER_62_147 VDD VSS sg13g2_decap_8
XFILLER_90_445 VDD VSS sg13g2_decap_4
XFILLER_31_501 VDD VSS sg13g2_decap_8
XFILLER_93_7 VDD VSS sg13g2_decap_8
X_2780_ _2780_/B _2780_/C _4939_/Q _2783_/B VDD VSS sg13g2_nand3_1
XFILLER_116_105 VDD VSS sg13g2_decap_8
XFILLER_7_284 VDD VSS sg13g2_decap_8
X_4450_ _4450_/RESET_B VSS VDD _4450_/D _4450_/Q _4966_/CLK sg13g2_dfrbpq_1
XFILLER_8_785 VDD VSS sg13g2_decap_4
X_4381_ _4381_/RESET_B VSS VDD _4381_/D _4381_/Q _4976_/CLK sg13g2_dfrbpq_1
X_3401_ _3493_/A _3424_/A _4903_/Q _3401_/D _3420_/A VDD VSS sg13g2_nor4_1
X_3332_ _3332_/Y _4789_/Q _4788_/Q VDD VSS sg13g2_nand2_1
XFILLER_112_322 VDD VSS sg13g2_decap_8
XFILLER_112_333 VDD VSS sg13g2_fill_2
XFILLER_113_867 VDD VSS sg13g2_fill_1
XFILLER_100_517 VDD VSS sg13g2_decap_8
XFILLER_39_601 VDD VSS sg13g2_decap_8
XFILLER_67_910 VDD VSS sg13g2_decap_8
XFILLER_85_206 VDD VSS sg13g2_decap_8
XFILLER_85_217 VDD VSS sg13g2_fill_2
X_3263_ _3263_/Y _3263_/A _3263_/B VDD VSS sg13g2_xnor2_1
XFILLER_66_420 VDD VSS sg13g2_decap_8
X_3194_ _2645_/A VDD _4581_/D VSS _3195_/A _3193_/B sg13g2_o21ai_1
XFILLER_15_0 VDD VSS sg13g2_decap_8
XFILLER_82_913 VDD VSS sg13g2_decap_8
XFILLER_94_751 VDD VSS sg13g2_decap_8
XFILLER_82_924 VDD VSS sg13g2_fill_2
XFILLER_19_391 VDD VSS sg13g2_decap_8
XFILLER_35_840 VDD VSS sg13g2_decap_8
XFILLER_53_158 VDD VSS sg13g2_decap_8
XFILLER_34_394 VDD VSS sg13g2_decap_8
XFILLER_50_843 VDD VSS sg13g2_decap_8
XFILLER_62_692 VDD VSS sg13g2_decap_8
XFILLER_14_38 VDD VSS sg13g2_decap_8
XFILLER_22_545 VDD VSS sg13g2_decap_8
X_2978_ hold862/X _3107_/A0 _2981_/S _4407_/D VDD VSS sg13g2_mux2_1
X_4717_ fanout332/X VSS VDD _4717_/D _4717_/Q _4933_/CLK sg13g2_dfrbpq_1
XFILLER_108_639 VDD VSS sg13g2_decap_4
X_4648_ fanout252/X VSS VDD _4648_/D _4648_/Q clkload2/A sg13g2_dfrbpq_1
XFILLER_30_48 VDD VSS sg13g2_decap_8
Xhold730 _3290_/X VDD VSS _4622_/D sg13g2_dlygate4sd3_1
Xhold763 _4580_/Q VDD VSS _2516_/C sg13g2_dlygate4sd3_1
Xhold752 _4495_/Q VDD VSS _3070_/A sg13g2_dlygate4sd3_1
Xhold741 _2747_/Y VDD VSS _2749_/B sg13g2_dlygate4sd3_1
X_4579_ fanout329/X VSS VDD _4579_/D _4579_/Q _4580_/CLK sg13g2_dfrbpq_1
XFILLER_89_501 VDD VSS sg13g2_decap_8
XFILLER_103_333 VDD VSS sg13g2_decap_8
XFILLER_115_171 VDD VSS sg13g2_decap_8
Xhold796 _4491_/Q VDD VSS hold796/X sg13g2_dlygate4sd3_1
Xhold785 _3541_/X VDD VSS _4703_/D sg13g2_dlygate4sd3_1
Xhold774 _4461_/Q VDD VSS hold774/X sg13g2_dlygate4sd3_1
XFILLER_103_366 VDD VSS sg13g2_decap_8
XFILLER_39_57 VDD VSS sg13g2_decap_8
XFILLER_69_280 VDD VSS sg13g2_decap_8
XFILLER_18_818 VDD VSS sg13g2_decap_4
Xhold1430 _3515_/Y VDD VSS _4687_/D sg13g2_dlygate4sd3_1
Xhold1441 _2426_/Y VDD VSS _4919_/D sg13g2_dlygate4sd3_1
Xhold1452 _4828_/Q VDD VSS _2634_/B sg13g2_dlygate4sd3_1
XFILLER_85_762 VDD VSS sg13g2_decap_8
XFILLER_29_155 VDD VSS sg13g2_decap_8
XFILLER_73_924 VDD VSS sg13g2_fill_2
Xhold1463 _3645_/X VDD VSS _4742_/D sg13g2_dlygate4sd3_1
Xhold1474 _4726_/Q VDD VSS _3604_/A sg13g2_dlygate4sd3_1
Xhold1485 _4542_/Q VDD VSS _3118_/A1 sg13g2_dlygate4sd3_1
Xhold1496 _2633_/Y VDD VSS _4842_/D sg13g2_dlygate4sd3_1
XFILLER_25_361 VDD VSS sg13g2_decap_4
XFILLER_72_467 VDD VSS sg13g2_decap_4
XFILLER_13_512 VDD VSS sg13g2_decap_4
XFILLER_13_578 VDD VSS sg13g2_decap_8
XFILLER_41_887 VDD VSS sg13g2_decap_4
XFILLER_40_397 VDD VSS sg13g2_decap_4
XFILLER_5_711 VDD VSS sg13g2_decap_8
XFILLER_113_108 VDD VSS sg13g2_fill_2
XFILLER_4_254 VDD VSS sg13g2_decap_8
XFILLER_5_788 VDD VSS sg13g2_decap_8
XFILLER_106_182 VDD VSS sg13g2_decap_8
XFILLER_64_924 VDD VSS sg13g2_fill_2
XFILLER_75_250 VDD VSS sg13g2_decap_8
XFILLER_76_773 VDD VSS sg13g2_decap_8
XFILLER_35_114 VDD VSS sg13g2_decap_8
XFILLER_35_125 VDD VSS sg13g2_fill_1
XFILLER_36_648 VDD VSS sg13g2_decap_8
XFILLER_63_423 VDD VSS sg13g2_decap_8
XFILLER_91_743 VDD VSS sg13g2_decap_8
XFILLER_23_309 VDD VSS sg13g2_decap_8
XFILLER_63_489 VDD VSS sg13g2_decap_8
X_3950_ _4821_/Q _3955_/A _4820_/Q _3951_/B VDD VSS sg13g2_nand3_1
XFILLER_50_117 VDD VSS sg13g2_decap_8
X_2901_ _2901_/A0 _3109_/A0 _2901_/S _2901_/X VDD VSS sg13g2_mux2_1
XFILLER_90_286 VDD VSS sg13g2_decap_8
X_3881_ _3881_/Y _3880_/Y _3939_/C _3879_/Y _2241_/Y VDD VSS sg13g2_a22oi_1
X_2832_ hold915/X _3094_/A0 _2848_/S _2832_/X VDD VSS sg13g2_mux2_1
X_2763_ _2784_/A _3528_/A _3294_/B VDD VSS sg13g2_nand2_1
X_4502_ fanout323/X VSS VDD _4502_/D _4502_/Q _4972_/CLK sg13g2_dfrbpq_1
XFILLER_6_50 VDD VSS sg13g2_decap_8
X_2694_ _2695_/C _3555_/A _3504_/B VDD VSS sg13g2_nand2_1
X_4433_ _4433_/RESET_B VSS VDD _4433_/D _4433_/Q _4966_/CLK sg13g2_dfrbpq_1
X_4364_ _4364_/RESET_B VSS VDD _4364_/D _4364_/Q _4958_/CLK sg13g2_dfrbpq_1
XFILLER_99_832 VDD VSS sg13g2_decap_8
XFILLER_98_331 VDD VSS sg13g2_decap_8
XFILLER_58_206 VDD VSS sg13g2_decap_8
X_4295_ _4295_/RESET_B VSS VDD _4295_/D _4295_/Q _4737_/CLK sg13g2_dfrbpq_1
X_3315_ _4776_/Q _4779_/Q _4778_/Q _4777_/Q _3412_/B VDD VSS sg13g2_or4_1
XFILLER_99_898 VDD VSS sg13g2_fill_2
XFILLER_99_876 VDD VSS sg13g2_fill_2
XFILLER_101_837 VDD VSS sg13g2_decap_8
XFILLER_112_174 VDD VSS sg13g2_fill_2
X_3246_ _2607_/C VDD _3246_/Y VSS _4602_/Q _4603_/Q sg13g2_o21ai_1
XFILLER_86_537 VDD VSS sg13g2_fill_1
XFILLER_100_369 VDD VSS sg13g2_decap_8
XFILLER_27_626 VDD VSS sg13g2_decap_4
XFILLER_39_464 VDD VSS sg13g2_decap_8
XFILLER_55_924 VDD VSS sg13g2_fill_2
X_3177_ _3182_/A _3177_/B _4574_/D VDD VSS sg13g2_nor2_1
XFILLER_82_743 VDD VSS sg13g2_fill_1
XFILLER_26_147 VDD VSS sg13g2_decap_8
XFILLER_42_629 VDD VSS sg13g2_fill_1
XFILLER_54_467 VDD VSS sg13g2_decap_8
XFILLER_35_692 VDD VSS sg13g2_decap_8
XFILLER_22_342 VDD VSS sg13g2_decap_8
XFILLER_23_854 VDD VSS sg13g2_decap_8
XFILLER_10_526 VDD VSS sg13g2_decap_8
XFILLER_50_673 VDD VSS sg13g2_decap_8
XFILLER_108_403 VDD VSS sg13g2_decap_8
XFILLER_41_69 VDD VSS sg13g2_decap_8
XFILLER_108_458 VDD VSS sg13g2_decap_4
XFILLER_104_620 VDD VSS sg13g2_decap_4
XFILLER_116_491 VDD VSS sg13g2_decap_8
XFILLER_2_736 VDD VSS sg13g2_decap_8
Xhold560 _2715_/Y VDD VSS _4870_/D sg13g2_dlygate4sd3_1
Xhold571 _2541_/Y VDD VSS _4874_/D sg13g2_dlygate4sd3_1
XFILLER_89_331 VDD VSS sg13g2_decap_8
XFILLER_104_675 VDD VSS sg13g2_decap_8
XFILLER_1_246 VDD VSS sg13g2_decap_8
Xhold582 _4880_/Q VDD VSS _2551_/B sg13g2_dlygate4sd3_1
Xhold593 _4833_/Q VDD VSS _3985_/A sg13g2_dlygate4sd3_1
XFILLER_49_206 VDD VSS sg13g2_decap_8
XFILLER_103_196 VDD VSS sg13g2_decap_8
XFILLER_66_77 VDD VSS sg13g2_decap_8
Xhold1260 _4172_/X VDD VSS _4178_/A2 sg13g2_dlygate4sd3_1
Xhold1271 _4335_/Q VDD VSS _2902_/A0 sg13g2_dlygate4sd3_1
Xhold1282 _4496_/Q VDD VSS _3072_/A1 sg13g2_dlygate4sd3_1
Xhold1293 _2907_/X VDD VSS _4339_/D sg13g2_dlygate4sd3_1
XFILLER_45_467 VDD VSS sg13g2_fill_1
XFILLER_32_106 VDD VSS sg13g2_decap_8
XFILLER_45_489 VDD VSS sg13g2_decap_8
XFILLER_72_275 VDD VSS sg13g2_decap_4
XFILLER_82_54 VDD VSS sg13g2_decap_8
XFILLER_14_865 VDD VSS sg13g2_decap_8
XFILLER_13_375 VDD VSS sg13g2_decap_8
XFILLER_13_386 VDD VSS sg13g2_decap_8
XFILLER_41_662 VDD VSS sg13g2_decap_8
XFILLER_13_397 VDD VSS sg13g2_fill_1
XFILLER_40_194 VDD VSS sg13g2_decap_8
XFILLER_9_357 VDD VSS sg13g2_decap_8
XFILLER_70_9 VDD VSS sg13g2_fill_1
XFILLER_31_91 VDD VSS sg13g2_decap_8
XFILLER_56_7 VDD VSS sg13g2_decap_8
XFILLER_5_563 VDD VSS sg13g2_fill_2
X_3100_ _3100_/A0 _3125_/A1 _3108_/S _4524_/D VDD VSS sg13g2_mux2_1
X_4080_ _4079_/Y VDD _4080_/Y VSS _4077_/Y _4078_/Y sg13g2_o21ai_1
XFILLER_49_784 VDD VSS sg13g2_fill_1
X_3031_ _3031_/A0 hold823/X _3033_/S _4457_/D VDD VSS sg13g2_mux2_1
XFILLER_95_367 VDD VSS sg13g2_decap_8
XFILLER_36_412 VDD VSS sg13g2_decap_8
XFILLER_48_272 VDD VSS sg13g2_decap_8
XFILLER_64_721 VDD VSS sg13g2_decap_8
XFILLER_24_607 VDD VSS sg13g2_decap_4
XFILLER_36_467 VDD VSS sg13g2_decap_4
XFILLER_91_540 VDD VSS sg13g2_fill_1
XFILLER_23_117 VDD VSS sg13g2_decap_4
XFILLER_36_489 VDD VSS sg13g2_fill_2
XFILLER_32_651 VDD VSS sg13g2_fill_2
X_3933_ VSS VDD _3948_/C _3929_/B _3933_/Y _3935_/A sg13g2_a21oi_1
X_3864_ _3866_/C _4927_/Q _3868_/A _4855_/Q VDD VSS sg13g2_and3_1
XFILLER_82_0 VDD VSS sg13g2_decap_8
X_2815_ VSS VDD _2814_/A _2814_/B _2815_/Y _2813_/A sg13g2_a21oi_1
X_3795_ _4761_/Q _3817_/B _3820_/B VDD VSS sg13g2_nor2_1
X_2746_ _2749_/A _2746_/B _4951_/D VDD VSS sg13g2_nor2_1
XFILLER_9_891 VDD VSS sg13g2_decap_8
XFILLER_105_406 VDD VSS sg13g2_decap_8
X_4298__428 VDD VSS _4298_/RESET_B sg13g2_tiehi
X_2677_ _2678_/C _2677_/A _4715_/Q VDD VSS sg13g2_nand2_1
X_4416_ _4416_/RESET_B VSS VDD _4416_/D _4416_/Q _4960_/CLK sg13g2_dfrbpq_1
Xfanout303 fanout304/X fanout303/X VDD VSS sg13g2_buf_1
Xfanout314 fanout319/X fanout314/X VDD VSS sg13g2_buf_1
XFILLER_101_612 VDD VSS sg13g2_decap_8
Xfanout325 fanout327/X fanout325/X VDD VSS sg13g2_buf_1
Xfanout336 fanout337/X fanout336/X VDD VSS sg13g2_buf_1
X_4347_ _4347_/RESET_B VSS VDD _4347_/D _4347_/Q _4397_/CLK sg13g2_dfrbpq_1
XFILLER_98_161 VDD VSS sg13g2_fill_1
XFILLER_101_645 VDD VSS sg13g2_decap_8
XFILLER_59_559 VDD VSS sg13g2_decap_8
X_4278_ _4278_/RESET_B VSS VDD _4278_/D _4278_/Q _4527_/CLK sg13g2_dfrbpq_1
XFILLER_100_144 VDD VSS sg13g2_decap_8
XFILLER_39_250 VDD VSS sg13g2_fill_1
X_3229_ _3229_/B _3229_/A _3229_/X VDD VSS sg13g2_xor2_1
XFILLER_36_14 VDD VSS sg13g2_decap_8
XFILLER_36_47 VDD VSS sg13g2_decap_4
XFILLER_42_404 VDD VSS sg13g2_decap_8
XFILLER_54_253 VDD VSS sg13g2_decap_8
XFILLER_70_702 VDD VSS sg13g2_decap_8
XFILLER_27_489 VDD VSS sg13g2_decap_8
XFILLER_42_437 VDD VSS sg13g2_decap_8
XFILLER_10_301 VDD VSS sg13g2_decap_8
XFILLER_52_35 VDD VSS sg13g2_decap_8
XFILLER_10_312 VDD VSS sg13g2_fill_2
XFILLER_22_194 VDD VSS sg13g2_fill_1
XFILLER_6_305 VDD VSS sg13g2_decap_8
XFILLER_109_756 VDD VSS sg13g2_decap_8
XFILLER_108_244 VDD VSS sg13g2_decap_8
X_4396__530 VDD VSS _4396_/RESET_B sg13g2_tiehi
XFILLER_111_409 VDD VSS sg13g2_decap_8
XFILLER_78_802 VDD VSS sg13g2_decap_8
XFILLER_78_824 VDD VSS sg13g2_fill_1
XFILLER_89_183 VDD VSS sg13g2_decap_8
XFILLER_77_345 VDD VSS sg13g2_decap_8
XFILLER_78_857 VDD VSS sg13g2_fill_1
XFILLER_65_507 VDD VSS sg13g2_decap_8
XFILLER_18_412 VDD VSS sg13g2_decap_8
XFILLER_18_467 VDD VSS sg13g2_decap_4
XFILLER_45_253 VDD VSS sg13g2_decap_4
Xhold1090 _4283_/Q VDD VSS _2846_/A0 sg13g2_dlygate4sd3_1
XFILLER_33_404 VDD VSS sg13g2_fill_1
XFILLER_14_640 VDD VSS sg13g2_decap_8
XFILLER_26_80 VDD VSS sg13g2_decap_4
XFILLER_61_779 VDD VSS sg13g2_decap_8
XFILLER_13_161 VDD VSS sg13g2_decap_8
XFILLER_13_183 VDD VSS sg13g2_fill_2
XFILLER_13_194 VDD VSS sg13g2_decap_8
XFILLER_9_110 VDD VSS sg13g2_decap_8
X_3580_ _3581_/B _3580_/A _3580_/B VDD VSS sg13g2_xnor2_1
X_2600_ _3229_/B _2601_/D _3232_/B VDD VSS sg13g2_nor2_1
XFILLER_6_861 VDD VSS sg13g2_decap_8
X_2531_ _2531_/Y _4773_/Q _4772_/Q VDD VSS sg13g2_nand2_1
XFILLER_102_409 VDD VSS sg13g2_decap_8
X_4201_ _4201_/Y _4201_/B _4121_/A VDD VSS sg13g2_nand2b_1
X_2462_ _2730_/A _2724_/B _2725_/A VDD VSS sg13g2_nor2_1
XFILLER_68_301 VDD VSS sg13g2_decap_8
X_2393_ _4912_/Q _4913_/Q _2395_/B VDD VSS sg13g2_nor2_1
XFILLER_96_621 VDD VSS sg13g2_decap_8
X_4132_ _4373_/Q _4398_/Q _4240_/A _4132_/X VDD VSS sg13g2_mux2_1
XFILLER_110_475 VDD VSS sg13g2_decap_8
XFILLER_49_570 VDD VSS sg13g2_decap_8
XFILLER_68_367 VDD VSS sg13g2_decap_8
X_4063_ _4245_/A1 VDD _4063_/Y VSS _4060_/Y _4061_/Y sg13g2_o21ai_1
X_3014_ hold934/X _4514_/Q _3034_/S _3014_/X VDD VSS sg13g2_mux2_1
XFILLER_64_562 VDD VSS sg13g2_decap_8
XFILLER_37_787 VDD VSS sg13g2_fill_1
XFILLER_51_212 VDD VSS sg13g2_decap_8
XFILLER_52_735 VDD VSS sg13g2_fill_1
XFILLER_40_919 VDD VSS sg13g2_decap_8
X_4965_ fanout314/X VSS VDD _4965_/D _4965_/Q _4965_/CLK sg13g2_dfrbpq_1
X_3916_ _3916_/Y _3948_/C _3919_/C VDD VSS sg13g2_nand2_1
XFILLER_60_790 VDD VSS sg13g2_decap_8
X_4896_ fanout319/X VSS VDD input3/X _4896_/Q _4931_/CLK sg13g2_dfrbpq_1
XFILLER_20_676 VDD VSS sg13g2_decap_8
X_3847_ _3848_/B _3847_/A _3847_/B VDD VSS sg13g2_xnor2_1
X_3778_ _3778_/Y _3847_/A _3788_/B VDD VSS sg13g2_nand2_1
XFILLER_4_809 VDD VSS sg13g2_decap_8
X_2729_ _2730_/D _2729_/B _2729_/Y VDD VSS sg13g2_nor2_1
XFILLER_102_921 VDD VSS sg13g2_decap_4
XFILLER_78_109 VDD VSS sg13g2_fill_1
Xfanout100 fanout99/A _2901_/S VDD VSS sg13g2_buf_1
Xfanout111 fanout113/X _2848_/S VDD VSS sg13g2_buf_1
Xfanout122 _2645_/Y _3654_/S VDD VSS sg13g2_buf_1
XFILLER_99_481 VDD VSS sg13g2_decap_8
XFILLER_101_420 VDD VSS sg13g2_decap_8
Xfanout133 _4188_/B1 _4225_/A1 VDD VSS sg13g2_buf_1
Xfanout144 _3288_/C1 _4006_/A VDD VSS sg13g2_buf_1
Xfanout155 _4850_/Q _3058_/S VDD VSS sg13g2_buf_1
XFILLER_59_389 VDD VSS sg13g2_decap_8
Xfanout166 fanout170/X _3999_/A VDD VSS sg13g2_buf_1
Xfanout177 _4254_/A1 _2348_/A VDD VSS sg13g2_buf_1
Xfanout188 fanout189/X fanout188/X VDD VSS sg13g2_buf_1
Xfanout199 _4187_/A _4222_/A VDD VSS sg13g2_buf_1
XFILLER_87_698 VDD VSS sg13g2_decap_8
XFILLER_101_486 VDD VSS sg13g2_decap_8
XFILLER_47_57 VDD VSS sg13g2_decap_8
XFILLER_74_348 VDD VSS sg13g2_fill_1
XFILLER_86_197 VDD VSS sg13g2_fill_2
XFILLER_86_175 VDD VSS sg13g2_decap_8
XFILLER_28_754 VDD VSS sg13g2_decap_8
XFILLER_90_808 VDD VSS sg13g2_fill_1
XFILLER_103_52 VDD VSS sg13g2_decap_8
XFILLER_15_415 VDD VSS sg13g2_decap_8
XFILLER_43_735 VDD VSS sg13g2_decap_8
XFILLER_31_908 VDD VSS sg13g2_decap_4
XFILLER_63_56 VDD VSS sg13g2_decap_8
XFILLER_11_665 VDD VSS sg13g2_decap_8
XFILLER_10_164 VDD VSS sg13g2_decap_8
XFILLER_6_113 VDD VSS sg13g2_decap_8
XFILLER_6_157 VDD VSS sg13g2_decap_8
XFILLER_2_330 VDD VSS sg13g2_decap_4
XFILLER_3_842 VDD VSS sg13g2_decap_8
XFILLER_98_919 VDD VSS sg13g2_fill_2
XFILLER_105_770 VDD VSS sg13g2_fill_1
XFILLER_111_217 VDD VSS sg13g2_decap_8
XFILLER_111_228 VDD VSS sg13g2_fill_2
XFILLER_69_109 VDD VSS sg13g2_decap_8
XFILLER_78_610 VDD VSS sg13g2_decap_8
XFILLER_88_97 VDD VSS sg13g2_decap_8
XFILLER_77_131 VDD VSS sg13g2_fill_2
XFILLER_66_838 VDD VSS sg13g2_decap_8
XFILLER_19_7 VDD VSS sg13g2_decap_8
XFILLER_19_732 VDD VSS sg13g2_decap_8
XFILLER_93_657 VDD VSS sg13g2_decap_8
XFILLER_18_231 VDD VSS sg13g2_decap_8
XFILLER_92_145 VDD VSS sg13g2_decap_8
XFILLER_33_212 VDD VSS sg13g2_decap_8
XFILLER_74_871 VDD VSS sg13g2_decap_8
XFILLER_22_908 VDD VSS sg13g2_decap_8
XFILLER_33_223 VDD VSS sg13g2_fill_2
XFILLER_73_381 VDD VSS sg13g2_decap_8
X_4288__438 VDD VSS _4288_/RESET_B sg13g2_tiehi
XFILLER_14_470 VDD VSS sg13g2_decap_4
XFILLER_42_790 VDD VSS sg13g2_decap_8
X_4750_ fanout270/X VSS VDD _4750_/D _4750_/Q _4942_/CLK sg13g2_dfrbpq_1
X_4681_ fanout255/X VSS VDD _4681_/D _4681_/Q clkload3/A sg13g2_dfrbpq_1
X_3701_ _3701_/Y _4744_/Q _3701_/B VDD VSS sg13g2_nand2_1
X_3632_ _3640_/B _3632_/B _3633_/B VDD VSS sg13g2_and2_1
XFILLER_115_523 VDD VSS sg13g2_decap_8
XFILLER_6_680 VDD VSS sg13g2_fill_1
X_3563_ _3563_/Y _3563_/A _3563_/B VDD VSS sg13g2_xnor2_1
XFILLER_45_0 VDD VSS sg13g2_decap_8
X_3494_ _4648_/Q VDD _3494_/Y VSS _3424_/A _3378_/C sg13g2_o21ai_1
X_2514_ _4574_/Q _4575_/Q _3176_/B _2514_/D _3186_/B VDD VSS sg13g2_or4_1
XFILLER_89_919 VDD VSS sg13g2_decap_8
XFILLER_102_206 VDD VSS sg13g2_decap_8
X_2445_ _2444_/Y VDD _4912_/D VSS _2433_/A _2805_/B sg13g2_o21ai_1
XFILLER_102_228 VDD VSS sg13g2_decap_4
XFILLER_111_740 VDD VSS sg13g2_decap_4
XFILLER_96_440 VDD VSS sg13g2_decap_4
XFILLER_68_153 VDD VSS sg13g2_decap_8
X_4115_ _4114_/Y VDD _4121_/B VSS _4111_/Y _4112_/Y sg13g2_o21ai_1
X_2376_ _2363_/X VDD _2386_/A VSS _4675_/Q _4667_/Q sg13g2_o21ai_1
XFILLER_96_473 VDD VSS sg13g2_decap_8
XFILLER_96_462 VDD VSS sg13g2_fill_2
XFILLER_110_283 VDD VSS sg13g2_decap_8
XFILLER_56_315 VDD VSS sg13g2_decap_8
XFILLER_57_838 VDD VSS sg13g2_fill_2
XFILLER_84_624 VDD VSS sg13g2_decap_8
XFILLER_56_359 VDD VSS sg13g2_decap_4
XFILLER_72_819 VDD VSS sg13g2_decap_8
XFILLER_83_156 VDD VSS sg13g2_decap_8
X_4046_ _4052_/A _4046_/B _4046_/Y VDD VSS sg13g2_nor2_1
XFILLER_25_702 VDD VSS sg13g2_decap_8
XFILLER_37_562 VDD VSS sg13g2_decap_8
XFILLER_71_329 VDD VSS sg13g2_decap_4
XFILLER_80_841 VDD VSS sg13g2_decap_8
XFILLER_92_690 VDD VSS sg13g2_decap_8
XFILLER_12_407 VDD VSS sg13g2_decap_8
XFILLER_52_576 VDD VSS sg13g2_decap_8
X_4948_ fanout276/X VSS VDD _4948_/D _4948_/Q _4954_/CLK sg13g2_dfrbpq_1
X_4879_ fanout303/X VSS VDD _4879_/D _4879_/Q _4884_/CLK sg13g2_dfrbpq_1
XFILLER_20_484 VDD VSS sg13g2_decap_4
XFILLER_106_512 VDD VSS sg13g2_fill_1
XFILLER_106_545 VDD VSS sg13g2_decap_8
XFILLER_0_823 VDD VSS sg13g2_decap_8
X_4393__533 VDD VSS _4393_/RESET_B sg13g2_tiehi
XFILLER_58_89 VDD VSS sg13g2_decap_8
XFILLER_75_613 VDD VSS sg13g2_decap_4
XFILLER_101_261 VDD VSS sg13g2_fill_1
XFILLER_59_186 VDD VSS sg13g2_fill_2
XFILLER_87_484 VDD VSS sg13g2_decap_8
XFILLER_90_605 VDD VSS sg13g2_decap_8
XFILLER_15_201 VDD VSS sg13g2_decap_8
XFILLER_56_893 VDD VSS sg13g2_decap_8
XFILLER_90_638 VDD VSS sg13g2_fill_2
XFILLER_74_99 VDD VSS sg13g2_decap_8
XFILLER_15_278 VDD VSS sg13g2_decap_8
XFILLER_31_705 VDD VSS sg13g2_fill_1
XFILLER_43_554 VDD VSS sg13g2_decap_8
XFILLER_71_896 VDD VSS sg13g2_decap_8
XFILLER_90_21 VDD VSS sg13g2_decap_4
XFILLER_30_215 VDD VSS sg13g2_decap_8
XFILLER_70_395 VDD VSS sg13g2_decap_8
XFILLER_90_87 VDD VSS sg13g2_decap_4
XFILLER_7_488 VDD VSS sg13g2_decap_8
XFILLER_109_394 VDD VSS sg13g2_decap_8
XFILLER_97_237 VDD VSS sg13g2_decap_8
XFILLER_39_816 VDD VSS sg13g2_fill_2
XFILLER_78_440 VDD VSS sg13g2_decap_8
XFILLER_65_112 VDD VSS sg13g2_decap_8
XFILLER_66_624 VDD VSS sg13g2_decap_8
XFILLER_78_495 VDD VSS sg13g2_fill_1
XFILLER_54_819 VDD VSS sg13g2_decap_8
XFILLER_19_584 VDD VSS sg13g2_decap_8
XFILLER_0_63 VDD VSS sg13g2_decap_8
XFILLER_19_595 VDD VSS sg13g2_fill_2
XFILLER_46_381 VDD VSS sg13g2_decap_8
XFILLER_62_830 VDD VSS sg13g2_decap_8
XFILLER_80_126 VDD VSS sg13g2_decap_8
XFILLER_21_204 VDD VSS sg13g2_decap_4
XFILLER_21_226 VDD VSS sg13g2_decap_8
XFILLER_22_738 VDD VSS sg13g2_decap_8
X_4802_ fanout290/X VSS VDD _4802_/D _4802_/Q _4807_/CLK sg13g2_dfrbpq_1
X_2994_ hold876/X _3096_/A0 _3002_/S _2994_/X VDD VSS sg13g2_mux2_1
X_4733_ fanout285/X VSS VDD _4733_/D _4733_/Q _4737_/CLK sg13g2_dfrbpq_1
X_4664_ fanout253/X VSS VDD _4664_/D _4664_/Q clkload2/A sg13g2_dfrbpq_1
XFILLER_116_810 VDD VSS sg13g2_decap_8
Xhold912 _2887_/X VDD VSS _4320_/D sg13g2_dlygate4sd3_1
Xhold901 _2900_/X VDD VSS _4333_/D sg13g2_dlygate4sd3_1
X_4595_ fanout289/X VSS VDD _4595_/D _4595_/Q _4807_/CLK sg13g2_dfrbpq_1
X_3615_ _3615_/Y _3615_/A _3615_/B VDD VSS sg13g2_nand2_1
XFILLER_115_331 VDD VSS sg13g2_decap_4
Xhold934 _4440_/Q VDD VSS hold934/X sg13g2_dlygate4sd3_1
Xhold945 _2847_/X VDD VSS _4284_/D sg13g2_dlygate4sd3_1
Xhold923 _3197_/Y VDD VSS hold923/X sg13g2_dlygate4sd3_1
X_3546_ _4708_/Q hold774/X _3550_/S _3546_/X VDD VSS sg13g2_mux2_1
XFILLER_116_887 VDD VSS sg13g2_decap_8
Xhold956 _2856_/X VDD VSS _4291_/D sg13g2_dlygate4sd3_1
Xhold967 _4466_/Q VDD VSS hold967/X sg13g2_dlygate4sd3_1
Xhold978 _3032_/X VDD VSS _4458_/D sg13g2_dlygate4sd3_1
Xhold989 _2995_/X VDD VSS _4422_/D sg13g2_dlygate4sd3_1
XFILLER_0_119 VDD VSS sg13g2_decap_8
X_3477_ _3489_/B _3477_/C _3477_/A _3477_/Y VDD VSS sg13g2_nand3_1
XFILLER_89_749 VDD VSS sg13g2_decap_8
Xhold1601 _3157_/Y VDD VSS _4565_/D sg13g2_dlygate4sd3_1
X_2428_ _3407_/A _2428_/B _2798_/B VDD VSS sg13g2_nor2_1
XFILLER_97_760 VDD VSS sg13g2_decap_4
XFILLER_28_37 VDD VSS sg13g2_decap_8
XFILLER_56_112 VDD VSS sg13g2_decap_8
XFILLER_57_613 VDD VSS sg13g2_decap_8
Xhold1612 _3234_/X VDD VSS _3235_/A2 sg13g2_dlygate4sd3_1
Xhold1623 _3186_/X VDD VSS _3187_/A2 sg13g2_dlygate4sd3_1
Xhold1634 _3240_/Y VDD VSS _3243_/B sg13g2_dlygate4sd3_1
X_2359_ _4648_/Q _3493_/A _2391_/A VDD VSS _3394_/A sg13g2_nand3b_1
XFILLER_29_359 VDD VSS sg13g2_decap_8
Xhold1645 _3180_/Y VDD VSS _4575_/D sg13g2_dlygate4sd3_1
Xhold1656 _3227_/Y VDD VSS _3228_/B sg13g2_dlygate4sd3_1
Xhold1667 _4904_/Q VDD VSS _2756_/A sg13g2_dlygate4sd3_1
Xhold1678 _4905_/Q VDD VSS _2405_/A sg13g2_dlygate4sd3_1
X_4029_ _4038_/A _4029_/B _4029_/Y VDD VSS sg13g2_nor2_1
XFILLER_25_521 VDD VSS sg13g2_decap_8
XFILLER_37_392 VDD VSS sg13g2_decap_8
XFILLER_44_14 VDD VSS sg13g2_decap_8
XFILLER_44_25 VDD VSS sg13g2_fill_1
XFILLER_25_554 VDD VSS sg13g2_fill_1
XFILLER_12_215 VDD VSS sg13g2_fill_2
XFILLER_12_226 VDD VSS sg13g2_decap_8
XFILLER_100_53 VDD VSS sg13g2_decap_8
XFILLER_100_75 VDD VSS sg13g2_decap_8
XFILLER_60_35 VDD VSS sg13g2_decap_8
XFILLER_60_57 VDD VSS sg13g2_fill_2
XFILLER_107_832 VDD VSS sg13g2_decap_8
XFILLER_69_55 VDD VSS sg13g2_decap_8
X_4278__448 VDD VSS _4278_/RESET_B sg13g2_tiehi
XFILLER_0_620 VDD VSS sg13g2_decap_8
XFILLER_88_760 VDD VSS sg13g2_decap_8
XFILLER_0_697 VDD VSS sg13g2_decap_8
XFILLER_75_421 VDD VSS sg13g2_fill_2
XFILLER_85_21 VDD VSS sg13g2_fill_2
XFILLER_91_925 VDD VSS sg13g2_fill_1
XFILLER_16_510 VDD VSS sg13g2_decap_8
XFILLER_62_115 VDD VSS sg13g2_fill_1
XFILLER_63_649 VDD VSS sg13g2_decap_8
XFILLER_90_424 VDD VSS sg13g2_decap_8
XFILLER_43_351 VDD VSS sg13g2_fill_1
XFILLER_44_874 VDD VSS sg13g2_fill_2
XFILLER_71_671 VDD VSS sg13g2_decap_8
XFILLER_70_170 VDD VSS sg13g2_decap_8
XFILLER_31_557 VDD VSS sg13g2_decap_8
XFILLER_12_782 VDD VSS sg13g2_decap_8
XFILLER_86_7 VDD VSS sg13g2_decap_8
XFILLER_12_793 VDD VSS sg13g2_fill_1
XFILLER_7_230 VDD VSS sg13g2_decap_8
XFILLER_8_764 VDD VSS sg13g2_decap_8
XFILLER_109_191 VDD VSS sg13g2_fill_2
X_4380_ _4380_/RESET_B VSS VDD _4380_/D _4380_/Q _4977_/CLK sg13g2_dfrbpq_1
X_3400_ _3400_/A _3400_/B _3405_/D VDD VSS sg13g2_nor2_1
X_3331_ VDD VSS _3329_/A _4787_/Q _3416_/B _3316_/X _3331_/Y _3329_/X sg13g2_a221oi_1
XFILLER_98_546 VDD VSS sg13g2_decap_8
XFILLER_67_900 VDD VSS sg13g2_fill_1
X_3262_ _3281_/A _3262_/B _4610_/D VDD VSS sg13g2_nor2_1
X_3193_ VSS VDD _3230_/A _3193_/B _3232_/A sg13g2_or2_1
XFILLER_94_730 VDD VSS sg13g2_decap_8
XFILLER_38_145 VDD VSS sg13g2_fill_2
XFILLER_54_627 VDD VSS sg13g2_decap_8
XFILLER_66_487 VDD VSS sg13g2_decap_8
XFILLER_19_370 VDD VSS sg13g2_fill_1
XFILLER_35_830 VDD VSS sg13g2_fill_1
XFILLER_81_424 VDD VSS sg13g2_decap_8
XFILLER_34_340 VDD VSS sg13g2_decap_8
XFILLER_22_513 VDD VSS sg13g2_decap_8
XFILLER_34_384 VDD VSS sg13g2_fill_1
XFILLER_50_822 VDD VSS sg13g2_decap_8
X_2977_ _2977_/A0 _3106_/A0 _2981_/S _4406_/D VDD VSS sg13g2_mux2_1
XFILLER_108_618 VDD VSS sg13g2_decap_8
X_4716_ fanout328/X VSS VDD _4716_/D _4716_/Q _4729_/CLK sg13g2_dfrbpq_1
X_4647_ fanout252/X VSS VDD _4647_/D _4647_/Q clkload2/A sg13g2_dfrbpq_1
XFILLER_107_139 VDD VSS sg13g2_decap_8
Xhold720 _4964_/Q VDD VSS _4109_/B sg13g2_dlygate4sd3_1
XFILLER_115_150 VDD VSS sg13g2_decap_8
XFILLER_116_662 VDD VSS sg13g2_fill_1
XFILLER_116_684 VDD VSS sg13g2_decap_8
XFILLER_2_918 VDD VSS sg13g2_decap_8
Xhold764 _3191_/Y VDD VSS _4580_/D sg13g2_dlygate4sd3_1
Xhold753 _3071_/Y VDD VSS _4495_/D sg13g2_dlygate4sd3_1
Xhold742 _2749_/Y VDD VSS _4952_/D sg13g2_dlygate4sd3_1
Xhold731 _4598_/Q VDD VSS _2599_/B sg13g2_dlygate4sd3_1
X_4578_ fanout329/X VSS VDD _4578_/D _4578_/Q _4580_/CLK sg13g2_dfrbpq_1
XFILLER_103_312 VDD VSS sg13g2_decap_8
XFILLER_104_846 VDD VSS sg13g2_decap_8
XFILLER_39_14 VDD VSS sg13g2_fill_2
Xhold797 _3040_/X VDD VSS _4466_/D sg13g2_dlygate4sd3_1
Xhold786 _4754_/Q VDD VSS _2344_/A sg13g2_dlygate4sd3_1
Xhold775 _3546_/X VDD VSS _4708_/D sg13g2_dlygate4sd3_1
X_3529_ _4932_/D _3529_/B _3529_/C _3529_/Y VDD VSS sg13g2_nor3_1
XFILLER_89_546 VDD VSS sg13g2_decap_8
XFILLER_39_36 VDD VSS sg13g2_decap_8
XFILLER_77_708 VDD VSS sg13g2_decap_8
XFILLER_29_112 VDD VSS sg13g2_decap_8
X_4390__536 VDD VSS _4390_/RESET_B sg13g2_tiehi
XFILLER_69_292 VDD VSS sg13g2_decap_8
Xhold1420 _3622_/X VDD VSS _4734_/D sg13g2_dlygate4sd3_1
Xhold1431 _4821_/Q VDD VSS _2251_/A sg13g2_dlygate4sd3_1
Xhold1442 _4616_/Q VDD VSS _3275_/A sg13g2_dlygate4sd3_1
XFILLER_55_35 VDD VSS sg13g2_decap_8
XFILLER_57_487 VDD VSS sg13g2_fill_1
Xhold1453 _4586_/Q VDD VSS _3204_/A sg13g2_dlygate4sd3_1
Xhold1464 _4635_/Q VDD VSS _3357_/B sg13g2_dlygate4sd3_1
Xhold1475 _4744_/Q VDD VSS _3648_/A0 sg13g2_dlygate4sd3_1
Xhold1486 _3118_/X VDD VSS _4542_/D sg13g2_dlygate4sd3_1
XFILLER_45_649 VDD VSS sg13g2_decap_4
XFILLER_72_446 VDD VSS sg13g2_decap_8
Xhold1497 _4647_/Q VDD VSS _3409_/A0 sg13g2_dlygate4sd3_1
XFILLER_25_340 VDD VSS sg13g2_decap_8
XFILLER_26_874 VDD VSS sg13g2_decap_8
XFILLER_111_63 VDD VSS sg13g2_decap_8
XFILLER_111_85 VDD VSS sg13g2_decap_8
XFILLER_41_866 VDD VSS sg13g2_decap_8
XFILLER_40_376 VDD VSS sg13g2_decap_8
XFILLER_112_0 VDD VSS sg13g2_decap_8
XFILLER_4_211 VDD VSS sg13g2_fill_2
XFILLER_4_233 VDD VSS sg13g2_decap_8
XFILLER_20_60 VDD VSS sg13g2_fill_1
XFILLER_5_767 VDD VSS sg13g2_decap_8
XFILLER_106_161 VDD VSS sg13g2_decap_8
XFILLER_110_805 VDD VSS sg13g2_decap_8
XFILLER_68_708 VDD VSS sg13g2_fill_2
XFILLER_96_53 VDD VSS sg13g2_decap_4
XFILLER_0_494 VDD VSS sg13g2_decap_8
XFILLER_76_741 VDD VSS sg13g2_fill_2
XFILLER_76_752 VDD VSS sg13g2_decap_8
XFILLER_29_91 VDD VSS sg13g2_fill_2
XFILLER_36_627 VDD VSS sg13g2_decap_8
XFILLER_48_476 VDD VSS sg13g2_decap_4
XFILLER_63_402 VDD VSS sg13g2_decap_8
X_2900_ hold900/X _3032_/A1 _2900_/S _2900_/X VDD VSS sg13g2_mux2_1
XFILLER_90_276 VDD VSS sg13g2_fill_1
XFILLER_43_181 VDD VSS sg13g2_decap_8
X_3880_ _3880_/Y _3911_/B _3889_/C VDD VSS sg13g2_nand2b_1
X_2831_ hold814/X _3017_/A1 _2846_/S _4268_/D VDD VSS sg13g2_mux2_1
XFILLER_31_398 VDD VSS sg13g2_decap_8
X_2762_ _2762_/B _2762_/C _2783_/A _3294_/B VDD VSS _2762_/D sg13g2_nand4_1
X_4501_ fanout308/X VSS VDD _4501_/D _4501_/Q _4978_/CLK sg13g2_dfrbpq_1
XFILLER_8_550 VDD VSS sg13g2_decap_8
X_4432_ _4432_/RESET_B VSS VDD _4432_/D _4432_/Q clkload9/A sg13g2_dfrbpq_1
X_2693_ _2692_/Y _2648_/Y _2693_/S _3504_/B VDD VSS sg13g2_mux2_1
X_4363_ _4363_/RESET_B VSS VDD _4363_/D _4363_/Q clkload9/A sg13g2_dfrbpq_1
XFILLER_99_855 VDD VSS sg13g2_decap_8
XFILLER_98_310 VDD VSS sg13g2_decap_8
XFILLER_101_816 VDD VSS sg13g2_decap_8
XFILLER_113_676 VDD VSS sg13g2_decap_8
X_4294_ _4294_/RESET_B VSS VDD _4294_/D _4294_/Q _4927_/CLK sg13g2_dfrbpq_1
X_3314_ _4776_/Q _4778_/Q _4777_/Q _3398_/C VDD VSS sg13g2_nor3_1
XFILLER_99_888 VDD VSS sg13g2_fill_2
XFILLER_113_687 VDD VSS sg13g2_fill_1
X_3245_ _3244_/Y _3242_/B _4006_/A _4603_/D VDD VSS sg13g2_a21o_1
XFILLER_39_443 VDD VSS sg13g2_decap_8
XFILLER_79_590 VDD VSS sg13g2_decap_8
XFILLER_55_903 VDD VSS sg13g2_decap_8
X_3176_ _3176_/B _3176_/A _3176_/X VDD VSS sg13g2_xor2_1
XFILLER_26_126 VDD VSS sg13g2_decap_8
XFILLER_27_649 VDD VSS sg13g2_fill_2
XFILLER_54_446 VDD VSS sg13g2_decap_8
XFILLER_82_733 VDD VSS sg13g2_fill_1
XFILLER_94_593 VDD VSS sg13g2_decap_8
XFILLER_42_608 VDD VSS sg13g2_decap_8
XFILLER_70_906 VDD VSS sg13g2_decap_8
XFILLER_81_265 VDD VSS sg13g2_fill_2
XFILLER_82_788 VDD VSS sg13g2_decap_4
XFILLER_25_49 VDD VSS sg13g2_decap_4
XFILLER_35_671 VDD VSS sg13g2_decap_8
XFILLER_81_298 VDD VSS sg13g2_decap_8
XFILLER_22_321 VDD VSS sg13g2_decap_8
Xclkbuf_leaf_61_clk clkbuf_4_0_0_clk/X _4907_/CLK VDD VSS sg13g2_buf_8
X_4268__458 VDD VSS _4268_/RESET_B sg13g2_tiehi
XFILLER_41_48 VDD VSS sg13g2_decap_8
XFILLER_108_437 VDD VSS sg13g2_fill_1
XFILLER_2_715 VDD VSS sg13g2_decap_8
XFILLER_116_470 VDD VSS sg13g2_decap_8
Xhold550 _4847_/Q VDD VSS _2458_/A sg13g2_dlygate4sd3_1
Xhold561 _4741_/Q VDD VSS _3636_/A sg13g2_dlygate4sd3_1
Xhold572 _4554_/Q VDD VSS _3132_/A sg13g2_dlygate4sd3_1
XFILLER_104_654 VDD VSS sg13g2_decap_8
Xhold583 _2553_/Y VDD VSS _2554_/B sg13g2_dlygate4sd3_1
Xhold594 _3986_/Y VDD VSS _4833_/D sg13g2_dlygate4sd3_1
XFILLER_77_516 VDD VSS sg13g2_decap_8
XFILLER_89_387 VDD VSS sg13g2_decap_8
XFILLER_106_74 VDD VSS sg13g2_decap_8
XFILLER_77_549 VDD VSS sg13g2_decap_8
XFILLER_100_882 VDD VSS sg13g2_decap_4
XFILLER_18_605 VDD VSS sg13g2_fill_1
XFILLER_46_925 VDD VSS sg13g2_fill_1
XFILLER_66_56 VDD VSS sg13g2_decap_8
Xhold1250 _4330_/Q VDD VSS _2897_/A0 sg13g2_dlygate4sd3_1
Xhold1261 _4745_/Q VDD VSS _2351_/A sg13g2_dlygate4sd3_1
XFILLER_92_508 VDD VSS sg13g2_fill_2
XFILLER_57_284 VDD VSS sg13g2_fill_1
XFILLER_72_221 VDD VSS sg13g2_decap_8
Xhold1272 _2902_/X VDD VSS _4335_/D sg13g2_dlygate4sd3_1
Xhold1283 _4906_/Q VDD VSS _2414_/B sg13g2_dlygate4sd3_1
Xhold1294 _4293_/Q VDD VSS _2858_/A0 sg13g2_dlygate4sd3_1
XFILLER_85_593 VDD VSS sg13g2_decap_8
XFILLER_82_11 VDD VSS sg13g2_fill_2
XFILLER_25_192 VDD VSS sg13g2_decap_4
Xclkbuf_leaf_52_clk clkbuf_4_8_0_clk/X _4968_/CLK VDD VSS sg13g2_buf_8
XFILLER_9_336 VDD VSS sg13g2_decap_8
XFILLER_115_908 VDD VSS sg13g2_decap_8
XFILLER_114_418 VDD VSS sg13g2_decap_4
XFILLER_107_492 VDD VSS sg13g2_decap_8
XFILLER_49_7 VDD VSS sg13g2_fill_1
XFILLER_0_280 VDD VSS sg13g2_decap_8
XFILLER_0_291 VDD VSS sg13g2_decap_8
XFILLER_110_646 VDD VSS sg13g2_decap_4
XFILLER_49_730 VDD VSS sg13g2_fill_1
XFILLER_95_346 VDD VSS sg13g2_decap_8
XFILLER_48_251 VDD VSS sg13g2_decap_8
XFILLER_49_763 VDD VSS sg13g2_decap_8
XFILLER_64_700 VDD VSS sg13g2_decap_8
XFILLER_76_560 VDD VSS sg13g2_decap_8
X_3030_ hold938/X hold811/X _3033_/S _4456_/D VDD VSS sg13g2_mux2_1
XFILLER_36_446 VDD VSS sg13g2_decap_8
XFILLER_63_287 VDD VSS sg13g2_decap_8
XFILLER_91_596 VDD VSS sg13g2_decap_8
XFILLER_16_170 VDD VSS sg13g2_fill_2
XFILLER_16_181 VDD VSS sg13g2_decap_8
Xclkbuf_leaf_43_clk clkbuf_4_11_0_clk/X _4869_/CLK VDD VSS sg13g2_buf_8
X_3932_ _3932_/A _3932_/B _4816_/D VDD VSS sg13g2_nor2_1
XFILLER_20_803 VDD VSS sg13g2_decap_8
XFILLER_20_814 VDD VSS sg13g2_fill_1
X_3863_ input7/X hold927/X _3863_/S _4799_/D VDD VSS sg13g2_mux2_1
XFILLER_31_184 VDD VSS sg13g2_decap_8
X_2814_ _2814_/A _2814_/B _2814_/Y VDD VSS sg13g2_nor2_1
XFILLER_75_0 VDD VSS sg13g2_decap_8
X_3794_ _4759_/Q _4760_/Q _4757_/Q _4758_/Q _3817_/B VDD VSS sg13g2_or4_1
XFILLER_9_870 VDD VSS sg13g2_decap_8
X_2745_ _2745_/Y _2745_/A _2748_/C VDD VSS sg13g2_xnor2_1
X_2676_ _2678_/B _4714_/Q _2677_/A VDD VSS sg13g2_nand2b_1
X_4415_ _4415_/RESET_B VSS VDD _4415_/D _4415_/Q _4964_/CLK sg13g2_dfrbpq_1
Xfanout304 fanout305/X fanout304/X VDD VSS sg13g2_buf_1
X_4346_ _4346_/RESET_B VSS VDD _4346_/D _4346_/Q _4965_/CLK sg13g2_dfrbpq_1
XFILLER_59_505 VDD VSS sg13g2_decap_8
XFILLER_59_516 VDD VSS sg13g2_fill_2
Xfanout315 fanout317/X fanout315/X VDD VSS sg13g2_buf_1
Xfanout326 fanout327/X fanout326/X VDD VSS sg13g2_buf_1
Xfanout337 input4/X fanout337/X VDD VSS sg13g2_buf_1
XFILLER_87_825 VDD VSS sg13g2_fill_1
XFILLER_87_814 VDD VSS sg13g2_decap_8
XFILLER_100_123 VDD VSS sg13g2_decap_8
X_4277_ _4277_/RESET_B VSS VDD _4277_/D _4277_/Q _4958_/CLK sg13g2_dfrbpq_1
XFILLER_98_195 VDD VSS sg13g2_fill_1
XFILLER_86_335 VDD VSS sg13g2_decap_8
XFILLER_28_925 VDD VSS sg13g2_fill_1
XFILLER_55_711 VDD VSS sg13g2_decap_4
XFILLER_67_560 VDD VSS sg13g2_fill_2
X_3228_ VSS VDD _4596_/D _3228_/B _3232_/A sg13g2_or2_1
XFILLER_86_379 VDD VSS sg13g2_decap_8
XFILLER_39_295 VDD VSS sg13g2_decap_8
XFILLER_82_530 VDD VSS sg13g2_decap_8
X_3159_ _3184_/B VDD _3159_/Y VSS _3179_/B1 _3159_/A2 sg13g2_o21ai_1
XFILLER_27_468 VDD VSS sg13g2_decap_8
XFILLER_43_917 VDD VSS sg13g2_decap_8
XFILLER_54_232 VDD VSS sg13g2_decap_8
XFILLER_42_416 VDD VSS sg13g2_decap_8
XFILLER_55_788 VDD VSS sg13g2_decap_8
XFILLER_52_14 VDD VSS sg13g2_decap_8
Xclkbuf_leaf_34_clk clkbuf_4_14_0_clk/X _4870_/CLK VDD VSS sg13g2_buf_8
XFILLER_10_357 VDD VSS sg13g2_decap_8
XFILLER_6_317 VDD VSS sg13g2_fill_1
XFILLER_108_223 VDD VSS sg13g2_decap_8
XFILLER_109_735 VDD VSS sg13g2_decap_8
XFILLER_6_339 VDD VSS sg13g2_decap_4
XFILLER_104_451 VDD VSS sg13g2_fill_1
XFILLER_77_302 VDD VSS sg13g2_decap_8
XFILLER_100_690 VDD VSS sg13g2_decap_8
XFILLER_45_232 VDD VSS sg13g2_decap_8
XFILLER_46_755 VDD VSS sg13g2_decap_8
XFILLER_61_703 VDD VSS sg13g2_decap_8
Xhold1080 _4660_/Q VDD VSS _3443_/A sg13g2_dlygate4sd3_1
Xhold1091 _2846_/X VDD VSS _4283_/D sg13g2_dlygate4sd3_1
XFILLER_45_276 VDD VSS sg13g2_decap_4
XFILLER_61_758 VDD VSS sg13g2_decap_8
Xclkbuf_leaf_25_clk clkbuf_4_13_0_clk/X _4965_/CLK VDD VSS sg13g2_buf_8
XFILLER_60_257 VDD VSS sg13g2_decap_8
XFILLER_9_133 VDD VSS sg13g2_decap_4
XFILLER_9_177 VDD VSS sg13g2_decap_8
XFILLER_6_840 VDD VSS sg13g2_decap_8
X_2530_ _4771_/Q _4769_/Q _4770_/Q _4768_/Q _2530_/Y VDD VSS sg13g2_nor4_1
X_2461_ _4948_/Q _2461_/B _4949_/Q _4950_/Q _2464_/C VDD VSS sg13g2_nor4_1
X_4200_ _4121_/A VDD _4200_/Y VSS _2348_/A _4194_/X sg13g2_o21ai_1
XFILLER_69_825 VDD VSS sg13g2_fill_1
X_5180_ _5180_/A _5180_/X VDD VSS sg13g2_buf_1
X_2392_ _4914_/Q _4915_/Q _2392_/C _2395_/A VDD VSS sg13g2_nor3_1
XFILLER_68_346 VDD VSS sg13g2_decap_8
X_4131_ _4130_/Y VDD _4131_/Y VSS _4128_/Y _4129_/Y sg13g2_o21ai_1
XFILLER_95_132 VDD VSS sg13g2_decap_8
XFILLER_110_454 VDD VSS sg13g2_decap_8
X_4062_ _4366_/Q _4391_/Q _4242_/S _4062_/X VDD VSS sg13g2_mux2_1
X_3013_ hold925/X _4513_/Q _3033_/S _3013_/X VDD VSS sg13g2_mux2_1
XFILLER_95_187 VDD VSS sg13g2_decap_8
XFILLER_37_744 VDD VSS sg13g2_decap_4
XFILLER_37_766 VDD VSS sg13g2_decap_8
XFILLER_64_541 VDD VSS sg13g2_decap_8
XFILLER_36_254 VDD VSS sg13g2_decap_8
XFILLER_36_287 VDD VSS sg13g2_decap_8
XFILLER_52_714 VDD VSS sg13g2_decap_8
XFILLER_51_246 VDD VSS sg13g2_fill_1
Xclkbuf_leaf_16_clk clkbuf_4_5_0_clk/X _4946_/CLK VDD VSS sg13g2_buf_8
X_4964_ fanout287/X VSS VDD _4964_/D _4964_/Q _4964_/CLK sg13g2_dfrbpq_1
XFILLER_91_382 VDD VSS sg13g2_decap_8
XFILLER_20_600 VDD VSS sg13g2_fill_1
X_3915_ _3915_/Y _3919_/A _3915_/B VDD VSS sg13g2_nand2_1
XFILLER_32_493 VDD VSS sg13g2_decap_8
X_4895_ fanout316/X VSS VDD input2/X _4895_/Q _4929_/CLK sg13g2_dfrbpq_1
XFILLER_20_655 VDD VSS sg13g2_decap_8
X_3846_ _3846_/Y _3852_/A _3845_/Y _3791_/S _3405_/A VDD VSS sg13g2_a22oi_1
X_3777_ VSS VDD _4770_/Q _3779_/C _3777_/Y _3847_/A sg13g2_a21oi_1
X_2728_ _2749_/A _2728_/B _2729_/B _4945_/D VDD VSS sg13g2_nor3_1
XFILLER_105_215 VDD VSS sg13g2_decap_4
X_2659_ _2660_/C _4706_/Q _2330_/A VDD VSS sg13g2_nand2b_1
Xfanout101 fanout99/A _2902_/S VDD VSS sg13g2_buf_1
Xfanout112 fanout113/X _2842_/S VDD VSS sg13g2_buf_1
XFILLER_87_611 VDD VSS sg13g2_decap_4
XFILLER_59_335 VDD VSS sg13g2_fill_1
XFILLER_59_346 VDD VSS sg13g2_decap_4
Xfanout123 _2741_/A _2749_/A VDD VSS sg13g2_buf_1
Xfanout134 _4188_/B1 _4199_/A1 VDD VSS sg13g2_buf_1
Xfanout145 _4927_/Q _3232_/A VDD VSS sg13g2_buf_1
Xfanout156 _4147_/B1 _4236_/B1 VDD VSS sg13g2_buf_1
X_4329_ _4329_/RESET_B VSS VDD _4329_/D _4329_/Q _4927_/CLK sg13g2_dfrbpq_1
XFILLER_47_14 VDD VSS sg13g2_decap_8
Xfanout167 fanout170/X _3987_/A VDD VSS sg13g2_buf_1
Xfanout178 _4254_/A1 _4189_/B1 VDD VSS sg13g2_buf_1
Xfanout189 _4826_/Q fanout189/X VDD VSS sg13g2_buf_1
XFILLER_87_677 VDD VSS sg13g2_decap_8
XFILLER_28_788 VDD VSS sg13g2_decap_8
XFILLER_43_714 VDD VSS sg13g2_decap_8
XFILLER_82_360 VDD VSS sg13g2_fill_1
XFILLER_82_371 VDD VSS sg13g2_fill_2
XFILLER_83_872 VDD VSS sg13g2_decap_8
XFILLER_83_883 VDD VSS sg13g2_fill_2
XFILLER_55_596 VDD VSS sg13g2_fill_2
XFILLER_63_35 VDD VSS sg13g2_decap_8
XFILLER_70_555 VDD VSS sg13g2_decap_4
XFILLER_11_600 VDD VSS sg13g2_fill_2
XFILLER_30_419 VDD VSS sg13g2_decap_8
XFILLER_42_257 VDD VSS sg13g2_decap_4
XFILLER_42_279 VDD VSS sg13g2_decap_8
XFILLER_70_588 VDD VSS sg13g2_decap_8
XFILLER_10_143 VDD VSS sg13g2_decap_8
XFILLER_7_626 VDD VSS sg13g2_decap_8
XFILLER_109_543 VDD VSS sg13g2_decap_8
XFILLER_109_554 VDD VSS sg13g2_fill_2
XFILLER_109_565 VDD VSS sg13g2_fill_1
XFILLER_3_821 VDD VSS sg13g2_decap_8
XFILLER_88_21 VDD VSS sg13g2_decap_4
XFILLER_5_0 VDD VSS sg13g2_decap_8
XFILLER_3_898 VDD VSS sg13g2_decap_8
XFILLER_88_76 VDD VSS sg13g2_decap_8
XFILLER_66_817 VDD VSS sg13g2_decap_8
XFILLER_19_711 VDD VSS sg13g2_decap_8
XFILLER_77_187 VDD VSS sg13g2_decap_8
XFILLER_78_699 VDD VSS sg13g2_fill_2
XFILLER_93_636 VDD VSS sg13g2_decap_8
XFILLER_92_124 VDD VSS sg13g2_decap_8
XFILLER_46_552 VDD VSS sg13g2_decap_4
XFILLER_58_390 VDD VSS sg13g2_decap_4
XFILLER_74_850 VDD VSS sg13g2_decap_8
XFILLER_18_287 VDD VSS sg13g2_decap_8
XFILLER_33_235 VDD VSS sg13g2_decap_8
XFILLER_21_408 VDD VSS sg13g2_decap_8
XFILLER_33_279 VDD VSS sg13g2_decap_8
X_3700_ _3722_/A _3718_/A _3700_/C _3701_/B VDD VSS sg13g2_nor3_1
X_4680_ fanout255/X VSS VDD _4680_/D _4680_/Q clkload3/A sg13g2_dfrbpq_1
X_3631_ _3719_/A VDD _3632_/B VSS _3718_/A _3700_/C sg13g2_o21ai_1
X_3562_ _3615_/A VDD _3562_/Y VSS _3590_/C _3523_/Y sg13g2_o21ai_1
XFILLER_115_502 VDD VSS sg13g2_decap_8
X_2513_ VSS VDD _2514_/D _4577_/Q _4576_/Q sg13g2_or2_1
X_3493_ _3493_/A _3493_/B _3493_/C _3495_/B VDD VSS sg13g2_nor3_1
Xclkbuf_leaf_5_clk clkbuf_4_3_0_clk/X _4658_/CLK VDD VSS sg13g2_buf_8
X_2444_ VSS VDD _2433_/A _2805_/B _2444_/Y _2807_/A sg13g2_a21oi_1
XFILLER_97_920 VDD VSS sg13g2_decap_4
XFILLER_38_0 VDD VSS sg13g2_decap_8
X_2375_ _2360_/Y VDD _2382_/B VSS _4682_/Q _4674_/Q sg13g2_o21ai_1
XFILLER_69_655 VDD VSS sg13g2_decap_8
XFILLER_69_666 VDD VSS sg13g2_fill_1
XFILLER_69_688 VDD VSS sg13g2_decap_8
XFILLER_84_603 VDD VSS sg13g2_decap_8
X_4114_ VSS VDD _4196_/B1 _4113_/X _4114_/Y _2348_/Y sg13g2_a21oi_1
XFILLER_110_262 VDD VSS sg13g2_decap_8
XFILLER_56_338 VDD VSS sg13g2_decap_8
XFILLER_37_541 VDD VSS sg13g2_decap_8
X_4045_ _4044_/Y VDD _4045_/Y VSS _4041_/Y _4043_/Y sg13g2_o21ai_1
XFILLER_65_883 VDD VSS sg13g2_decap_8
XFILLER_80_820 VDD VSS sg13g2_decap_8
XFILLER_24_224 VDD VSS sg13g2_fill_1
XFILLER_25_747 VDD VSS sg13g2_decap_8
XFILLER_52_533 VDD VSS sg13g2_decap_8
XFILLER_40_717 VDD VSS sg13g2_decap_8
XFILLER_40_739 VDD VSS sg13g2_fill_1
X_4947_ fanout276/X VSS VDD _4947_/D _4947_/Q _4954_/CLK sg13g2_dfrbpq_1
XFILLER_20_430 VDD VSS sg13g2_fill_2
X_4878_ fanout303/X VSS VDD _4878_/D _4878_/Q _4884_/CLK sg13g2_dfrbpq_1
XFILLER_20_463 VDD VSS sg13g2_decap_8
X_3829_ _3830_/B _3829_/A _3829_/B VDD VSS sg13g2_xnor2_1
XFILLER_116_7 VDD VSS sg13g2_decap_8
XFILLER_3_117 VDD VSS sg13g2_decap_4
XFILLER_0_802 VDD VSS sg13g2_decap_8
XFILLER_87_430 VDD VSS sg13g2_decap_8
XFILLER_0_879 VDD VSS sg13g2_decap_8
XFILLER_101_240 VDD VSS sg13g2_decap_8
XFILLER_102_763 VDD VSS sg13g2_decap_8
XFILLER_58_68 VDD VSS sg13g2_decap_8
XFILLER_58_79 VDD VSS sg13g2_fill_1
XFILLER_102_796 VDD VSS sg13g2_decap_8
XFILLER_74_113 VDD VSS sg13g2_decap_8
XFILLER_47_349 VDD VSS sg13g2_decap_8
XFILLER_59_198 VDD VSS sg13g2_decap_8
XFILLER_74_124 VDD VSS sg13g2_fill_2
XFILLER_74_34 VDD VSS sg13g2_fill_2
XFILLER_114_96 VDD VSS sg13g2_decap_8
XFILLER_28_585 VDD VSS sg13g2_decap_8
XFILLER_56_872 VDD VSS sg13g2_decap_8
XFILLER_43_522 VDD VSS sg13g2_decap_4
XFILLER_55_393 VDD VSS sg13g2_decap_8
XFILLER_74_78 VDD VSS sg13g2_decap_8
XFILLER_15_246 VDD VSS sg13g2_decap_8
XFILLER_82_190 VDD VSS sg13g2_decap_8
XFILLER_31_728 VDD VSS sg13g2_fill_2
XFILLER_31_739 VDD VSS sg13g2_decap_4
XFILLER_70_374 VDD VSS sg13g2_decap_8
XFILLER_23_82 VDD VSS sg13g2_decap_8
XFILLER_109_373 VDD VSS sg13g2_decap_8
XFILLER_79_920 VDD VSS sg13g2_decap_4
XFILLER_97_216 VDD VSS sg13g2_decap_4
XFILLER_31_7 VDD VSS sg13g2_decap_8
XFILLER_3_695 VDD VSS sg13g2_decap_8
X_4294__432 VDD VSS _4294_/RESET_B sg13g2_tiehi
XFILLER_38_338 VDD VSS sg13g2_decap_8
XFILLER_81_606 VDD VSS sg13g2_fill_2
XFILLER_93_444 VDD VSS sg13g2_fill_2
XFILLER_0_42 VDD VSS sg13g2_decap_8
XFILLER_19_563 VDD VSS sg13g2_decap_8
XFILLER_47_872 VDD VSS sg13g2_decap_8
XFILLER_80_105 VDD VSS sg13g2_decap_8
XFILLER_81_617 VDD VSS sg13g2_fill_2
XFILLER_93_488 VDD VSS sg13g2_decap_8
XFILLER_34_522 VDD VSS sg13g2_fill_2
XFILLER_46_371 VDD VSS sg13g2_fill_1
XFILLER_34_566 VDD VSS sg13g2_decap_8
XFILLER_62_886 VDD VSS sg13g2_decap_8
XFILLER_61_385 VDD VSS sg13g2_decap_8
X_4801_ fanout292/X VSS VDD _4801_/D _4801_/Q _4807_/CLK sg13g2_dfrbpq_1
X_2993_ _2993_/A0 _3095_/A0 _3008_/S _4420_/D VDD VSS sg13g2_mux2_1
X_4732_ fanout285/X VSS VDD _4732_/D _4732_/Q _4737_/CLK sg13g2_dfrbpq_1
XFILLER_9_62 VDD VSS sg13g2_decap_8
X_4663_ fanout253/X VSS VDD _4663_/D _4663_/Q clkload2/A sg13g2_dfrbpq_1
XFILLER_30_794 VDD VSS sg13g2_decap_8
X_3614_ _3615_/B _3614_/A _3614_/B VDD VSS sg13g2_xnor2_1
Xhold913 _4430_/Q VDD VSS hold913/X sg13g2_dlygate4sd3_1
Xhold902 _4444_/Q VDD VSS hold902/X sg13g2_dlygate4sd3_1
X_4594_ fanout289/X VSS VDD _4594_/D _4594_/Q _4807_/CLK sg13g2_dfrbpq_1
XFILLER_115_310 VDD VSS sg13g2_decap_8
XFILLER_116_866 VDD VSS sg13g2_decap_8
Xhold935 _3014_/X VDD VSS _4440_/D sg13g2_dlygate4sd3_1
Xhold946 _4544_/Q VDD VSS hold946/X sg13g2_dlygate4sd3_1
Xhold924 _3199_/Y VDD VSS _4583_/D sg13g2_dlygate4sd3_1
X_3545_ _3545_/A0 hold894/X _3551_/S _4707_/D VDD VSS sg13g2_mux2_1
Xhold957 _4662_/Q VDD VSS _3447_/A sg13g2_dlygate4sd3_1
Xhold968 _3551_/X VDD VSS _4713_/D sg13g2_dlygate4sd3_1
Xhold979 _4324_/Q VDD VSS hold979/X sg13g2_dlygate4sd3_1
X_3476_ _3475_/Y VDD _3476_/Y VSS _2277_/Y _3473_/C sg13g2_o21ai_1
X_2427_ _2792_/A _2792_/B _2793_/B VDD VSS sg13g2_and2_1
XFILLER_88_249 VDD VSS sg13g2_decap_8
Xclkbuf_4_15_0_clk clkbuf_0_clk/X clkbuf_4_15_0_clk/X VDD VSS sg13g2_buf_8
XFILLER_69_496 VDD VSS sg13g2_decap_8
Xhold1602 _4802_/Q VDD VSS _3877_/A sg13g2_dlygate4sd3_1
Xhold1613 _4852_/Q VDD VSS _2354_/A sg13g2_dlygate4sd3_1
Xhold1624 _3187_/Y VDD VSS _4578_/D sg13g2_dlygate4sd3_1
Xhold1635 _4809_/Q VDD VSS _3899_/A sg13g2_dlygate4sd3_1
X_2358_ VDD _2358_/Y _2358_/A VSS sg13g2_inv_1
XFILLER_29_338 VDD VSS sg13g2_decap_8
XFILLER_57_669 VDD VSS sg13g2_decap_8
Xhold1646 _4820_/Q VDD VSS _3944_/B sg13g2_dlygate4sd3_1
Xhold1657 _4783_/Q VDD VSS _2318_/A sg13g2_dlygate4sd3_1
Xhold1668 _4757_/Q VDD VSS hold1668/X sg13g2_dlygate4sd3_1
X_2289_ VDD _2289_/Y _3485_/A VSS sg13g2_inv_1
XFILLER_44_319 VDD VSS sg13g2_fill_2
XFILLER_56_168 VDD VSS sg13g2_decap_4
XFILLER_72_639 VDD VSS sg13g2_decap_4
XFILLER_84_466 VDD VSS sg13g2_fill_1
Xhold1679 _4951_/Q VDD VSS _2748_/A sg13g2_dlygate4sd3_1
X_4028_ _4038_/A _4263_/Q _4028_/A1 _4313_/Q _4338_/Q _4172_/S1 _4028_/X VDD VSS sg13g2_mux4_1
XFILLER_84_499 VDD VSS sg13g2_decap_8
XFILLER_25_544 VDD VSS sg13g2_fill_2
XFILLER_80_650 VDD VSS sg13g2_decap_8
XFILLER_100_21 VDD VSS sg13g2_decap_8
XFILLER_13_728 VDD VSS sg13g2_decap_8
XFILLER_100_43 VDD VSS sg13g2_fill_1
XFILLER_40_569 VDD VSS sg13g2_decap_4
XFILLER_100_98 VDD VSS sg13g2_fill_1
XFILLER_60_14 VDD VSS sg13g2_decap_8
XFILLER_20_293 VDD VSS sg13g2_decap_8
XFILLER_107_811 VDD VSS sg13g2_fill_2
XFILLER_114_4 VDD VSS sg13g2_decap_8
XFILLER_106_310 VDD VSS sg13g2_decap_8
XFILLER_4_437 VDD VSS sg13g2_fill_2
XFILLER_109_85 VDD VSS sg13g2_decap_8
XFILLER_106_398 VDD VSS sg13g2_fill_1
XFILLER_79_216 VDD VSS sg13g2_decap_8
XFILLER_94_208 VDD VSS sg13g2_decap_4
XFILLER_0_676 VDD VSS sg13g2_decap_8
XFILLER_47_113 VDD VSS sg13g2_decap_8
XFILLER_75_400 VDD VSS sg13g2_decap_8
XFILLER_88_794 VDD VSS sg13g2_decap_8
XFILLER_36_809 VDD VSS sg13g2_decap_8
XFILLER_75_455 VDD VSS sg13g2_decap_8
XFILLER_91_904 VDD VSS sg13g2_decap_8
XFILLER_85_66 VDD VSS sg13g2_decap_8
XFILLER_29_861 VDD VSS sg13g2_decap_8
XFILLER_35_308 VDD VSS sg13g2_decap_8
XFILLER_90_403 VDD VSS sg13g2_decap_8
XFILLER_44_853 VDD VSS sg13g2_decap_8
XFILLER_71_650 VDD VSS sg13g2_decap_8
XFILLER_31_536 VDD VSS sg13g2_decap_8
XFILLER_43_396 VDD VSS sg13g2_decap_8
XFILLER_12_761 VDD VSS sg13g2_decap_4
XFILLER_11_260 VDD VSS sg13g2_fill_1
XFILLER_11_282 VDD VSS sg13g2_decap_8
XFILLER_79_7 VDD VSS sg13g2_decap_8
XFILLER_8_798 VDD VSS sg13g2_decap_4
XFILLER_109_170 VDD VSS sg13g2_decap_4
X_3330_ VSS VDD _3416_/B _4785_/Q _4784_/Q sg13g2_or2_1
XFILLER_98_503 VDD VSS sg13g2_decap_4
XFILLER_113_858 VDD VSS sg13g2_decap_8
XFILLER_98_525 VDD VSS sg13g2_decap_8
X_3261_ _3263_/B _3260_/Y _3262_/B VDD VSS sg13g2_nor2b_1
XFILLER_112_379 VDD VSS sg13g2_decap_4
XFILLER_78_271 VDD VSS sg13g2_decap_4
X_3192_ _3192_/A _3193_/B _3192_/X VDD VSS sg13g2_and2_1
XFILLER_38_179 VDD VSS sg13g2_decap_8
XFILLER_94_786 VDD VSS sg13g2_decap_8
XFILLER_93_252 VDD VSS sg13g2_decap_8
XFILLER_35_875 VDD VSS sg13g2_decap_8
XFILLER_46_190 VDD VSS sg13g2_decap_8
XFILLER_50_801 VDD VSS sg13g2_decap_8
XFILLER_50_878 VDD VSS sg13g2_decap_8
XFILLER_61_193 VDD VSS sg13g2_decap_8
X_2976_ _2976_/A0 _3105_/A0 _2979_/S _4405_/D VDD VSS sg13g2_mux2_1
X_4715_ fanout323/X VSS VDD _4715_/D _4715_/Q _4729_/CLK sg13g2_dfrbpq_1
XFILLER_107_118 VDD VSS sg13g2_decap_8
XFILLER_30_28 VDD VSS sg13g2_decap_8
X_4646_ fanout272/X VSS VDD _4646_/D _4646_/Q _4749_/CLK sg13g2_dfrbpq_1
XFILLER_116_641 VDD VSS sg13g2_decap_8
XFILLER_30_39 VDD VSS sg13g2_fill_2
Xhold721 _4110_/Y VDD VSS _4964_/D sg13g2_dlygate4sd3_1
Xhold710 _4774_/Q VDD VSS _3807_/A sg13g2_dlygate4sd3_1
X_4577_ fanout330/X VSS VDD _4577_/D _4577_/Q _4580_/CLK sg13g2_dfrbpq_1
Xhold754 _4751_/Q VDD VSS _2341_/A sg13g2_dlygate4sd3_1
Xhold743 _4615_/Q VDD VSS _3273_/B sg13g2_dlygate4sd3_1
Xhold732 _3231_/Y VDD VSS hold732/X sg13g2_dlygate4sd3_1
XFILLER_1_429 VDD VSS sg13g2_decap_8
Xhold787 _3720_/Y VDD VSS _4754_/D sg13g2_dlygate4sd3_1
Xhold776 _4665_/Q VDD VSS _3453_/A sg13g2_dlygate4sd3_1
Xhold765 _4819_/Q VDD VSS _3944_/A sg13g2_dlygate4sd3_1
X_3528_ _3528_/A _3556_/B _3529_/C VDD VSS sg13g2_nor2_1
XFILLER_89_525 VDD VSS sg13g2_fill_2
Xhold798 _4510_/Q VDD VSS hold798/X sg13g2_dlygate4sd3_1
X_3459_ _3473_/B _3475_/C _3459_/A _3459_/Y VDD VSS sg13g2_nand3_1
XFILLER_58_923 VDD VSS sg13g2_fill_2
Xhold1410 _4719_/Q VDD VSS _2700_/A sg13g2_dlygate4sd3_1
XFILLER_85_720 VDD VSS sg13g2_decap_8
XFILLER_112_891 VDD VSS sg13g2_fill_2
XFILLER_29_135 VDD VSS sg13g2_fill_2
Xhold1421 _4942_/Q VDD VSS _3288_/C1 sg13g2_dlygate4sd3_1
Xhold1432 _3949_/Y VDD VSS _4821_/D sg13g2_dlygate4sd3_1
Xhold1443 _3275_/X VDD VSS _3276_/B sg13g2_dlygate4sd3_1
XFILLER_45_628 VDD VSS sg13g2_decap_8
XFILLER_55_14 VDD VSS sg13g2_decap_8
XFILLER_84_252 VDD VSS sg13g2_decap_8
XFILLER_84_263 VDD VSS sg13g2_fill_1
Xhold1454 _3204_/Y VDD VSS _3205_/A2 sg13g2_dlygate4sd3_1
Xhold1465 _4584_/Q VDD VSS _3200_/A sg13g2_dlygate4sd3_1
Xhold1476 _4605_/Q VDD VSS _3249_/A sg13g2_dlygate4sd3_1
XFILLER_26_820 VDD VSS sg13g2_fill_2
XFILLER_72_425 VDD VSS sg13g2_decap_8
XFILLER_84_296 VDD VSS sg13g2_fill_1
Xhold1487 _4673_/Q VDD VSS _3469_/A sg13g2_dlygate4sd3_1
Xhold1498 _4772_/Q VDD VSS _2292_/A sg13g2_dlygate4sd3_1
XFILLER_40_355 VDD VSS sg13g2_decap_8
X_4284__442 VDD VSS _4284_/RESET_B sg13g2_tiehi
XFILLER_21_591 VDD VSS sg13g2_decap_8
XFILLER_107_641 VDD VSS sg13g2_decap_4
XFILLER_5_746 VDD VSS sg13g2_decap_8
XFILLER_105_0 VDD VSS sg13g2_decap_8
XFILLER_20_83 VDD VSS sg13g2_decap_8
XFILLER_4_289 VDD VSS sg13g2_decap_8
XFILLER_96_43 VDD VSS sg13g2_fill_1
XFILLER_96_21 VDD VSS sg13g2_decap_8
XFILLER_0_473 VDD VSS sg13g2_decap_8
XFILLER_96_76 VDD VSS sg13g2_decap_8
X_4291__435 VDD VSS _4291_/RESET_B sg13g2_tiehi
XFILLER_29_81 VDD VSS sg13g2_fill_1
XFILLER_48_455 VDD VSS sg13g2_decap_8
XFILLER_75_263 VDD VSS sg13g2_fill_1
XFILLER_29_680 VDD VSS sg13g2_decap_8
XFILLER_90_211 VDD VSS sg13g2_fill_2
XFILLER_17_853 VDD VSS sg13g2_decap_8
XFILLER_90_255 VDD VSS sg13g2_decap_8
XFILLER_43_160 VDD VSS sg13g2_decap_8
XFILLER_44_694 VDD VSS sg13g2_decap_8
XFILLER_31_344 VDD VSS sg13g2_fill_2
X_2830_ hold930/X _3092_/A0 _2848_/S _4267_/D VDD VSS sg13g2_mux2_1
XFILLER_12_591 VDD VSS sg13g2_decap_4
X_2761_ _2771_/B _2766_/A _2762_/D VDD VSS sg13g2_nor2b_1
X_4500_ fanout322/X VSS VDD _4500_/D _4500_/Q _4979_/CLK sg13g2_dfrbpq_1
X_2692_ _2692_/A _2692_/B _2692_/C _2692_/Y VDD VSS sg13g2_nor3_1
XANTENNA_1 VDD VSS _4645_/Q sg13g2_antennanp
X_4431_ _4431_/RESET_B VSS VDD _4431_/D _4431_/Q _4976_/CLK sg13g2_dfrbpq_1
XFILLER_8_584 VDD VSS sg13g2_decap_8
XFILLER_6_85 VDD VSS sg13g2_decap_8
XFILLER_113_611 VDD VSS sg13g2_fill_1
X_4362_ _4362_/RESET_B VSS VDD _4362_/D _4362_/Q _4959_/CLK sg13g2_dfrbpq_1
X_4293_ _4293_/RESET_B VSS VDD _4293_/D _4293_/Q clkload7/A sg13g2_dfrbpq_1
X_3313_ _3337_/D VDD _3313_/Y VSS _3310_/Y _3312_/Y sg13g2_o21ai_1
XFILLER_99_878 VDD VSS sg13g2_fill_1
XFILLER_112_176 VDD VSS sg13g2_fill_1
X_3244_ _3244_/Y _3244_/A _3244_/B VDD VSS sg13g2_xnor2_1
XFILLER_98_377 VDD VSS sg13g2_decap_8
XFILLER_86_528 VDD VSS sg13g2_decap_8
XFILLER_100_327 VDD VSS sg13g2_decap_8
XFILLER_20_0 VDD VSS sg13g2_decap_8
XFILLER_67_742 VDD VSS sg13g2_fill_2
XFILLER_27_617 VDD VSS sg13g2_decap_4
XFILLER_67_786 VDD VSS sg13g2_fill_2
X_3175_ _3182_/A _3175_/B _4573_/D VDD VSS sg13g2_nor2_1
XFILLER_26_116 VDD VSS sg13g2_fill_2
XFILLER_54_425 VDD VSS sg13g2_decap_8
XFILLER_35_650 VDD VSS sg13g2_decap_8
XFILLER_82_767 VDD VSS sg13g2_decap_8
XFILLER_22_300 VDD VSS sg13g2_decap_8
XFILLER_23_801 VDD VSS sg13g2_decap_8
XFILLER_25_28 VDD VSS sg13g2_decap_8
XFILLER_81_277 VDD VSS sg13g2_decap_8
XFILLER_34_182 VDD VSS sg13g2_decap_8
XFILLER_50_653 VDD VSS sg13g2_fill_2
XFILLER_109_906 VDD VSS sg13g2_decap_8
X_2959_ _4031_/A1 _3088_/A0 _2979_/S _4388_/D VDD VSS sg13g2_mux2_1
X_4629_ fanout263/X VSS VDD _4629_/D _4629_/Q _4673_/CLK sg13g2_dfrbpq_1
XFILLER_1_204 VDD VSS sg13g2_fill_2
XFILLER_1_215 VDD VSS sg13g2_decap_8
Xhold540 _4901_/Q VDD VSS _2501_/A sg13g2_dlygate4sd3_1
Xhold551 _2458_/Y VDD VSS _4844_/D sg13g2_dlygate4sd3_1
Xhold562 _3644_/Y VDD VSS _4741_/D sg13g2_dlygate4sd3_1
X_4459__467 VDD VSS _4459_/RESET_B sg13g2_tiehi
XFILLER_9_7 VDD VSS sg13g2_decap_8
XFILLER_104_633 VDD VSS sg13g2_decap_8
Xhold573 _3133_/Y VDD VSS _4554_/D sg13g2_dlygate4sd3_1
Xhold584 _2554_/Y VDD VSS _4880_/D sg13g2_dlygate4sd3_1
Xhold595 _4834_/Q VDD VSS _3989_/A sg13g2_dlygate4sd3_1
XFILLER_77_528 VDD VSS sg13g2_decap_8
XFILLER_89_366 VDD VSS sg13g2_decap_8
XFILLER_66_35 VDD VSS sg13g2_decap_8
XFILLER_100_861 VDD VSS sg13g2_decap_8
Xhold1240 _4360_/Q VDD VSS _2928_/A0 sg13g2_dlygate4sd3_1
Xhold1251 _4341_/Q VDD VSS _2909_/A0 sg13g2_dlygate4sd3_1
XFILLER_85_561 VDD VSS sg13g2_decap_8
XFILLER_17_127 VDD VSS sg13g2_decap_8
Xhold1262 _4356_/Q VDD VSS _2924_/A0 sg13g2_dlygate4sd3_1
Xhold1273 _4409_/Q VDD VSS _2980_/A0 sg13g2_dlygate4sd3_1
Xhold1284 _2795_/Y VDD VSS _4906_/D sg13g2_dlygate4sd3_1
Xhold1295 _4323_/Q VDD VSS _2890_/A0 sg13g2_dlygate4sd3_1
XFILLER_13_300 VDD VSS sg13g2_decap_8
XFILLER_14_812 VDD VSS sg13g2_decap_8
XFILLER_60_406 VDD VSS sg13g2_decap_8
XFILLER_73_789 VDD VSS sg13g2_decap_8
XFILLER_25_171 VDD VSS sg13g2_decap_8
XFILLER_53_480 VDD VSS sg13g2_decap_8
XFILLER_13_355 VDD VSS sg13g2_decap_8
XFILLER_40_130 VDD VSS sg13g2_fill_2
XFILLER_9_315 VDD VSS sg13g2_decap_8
XFILLER_15_94 VDD VSS sg13g2_decap_8
XFILLER_40_174 VDD VSS sg13g2_fill_2
XFILLER_114_408 VDD VSS sg13g2_fill_1
XFILLER_107_471 VDD VSS sg13g2_decap_8
XFILLER_99_119 VDD VSS sg13g2_decap_8
XFILLER_110_625 VDD VSS sg13g2_decap_8
XFILLER_68_539 VDD VSS sg13g2_decap_8
XFILLER_95_314 VDD VSS sg13g2_decap_8
XFILLER_1_782 VDD VSS sg13g2_decap_8
XFILLER_37_915 VDD VSS sg13g2_decap_8
XFILLER_48_230 VDD VSS sg13g2_decap_8
XFILLER_63_211 VDD VSS sg13g2_decap_8
XFILLER_64_767 VDD VSS sg13g2_decap_8
XFILLER_64_778 VDD VSS sg13g2_fill_2
XFILLER_91_575 VDD VSS sg13g2_decap_8
XFILLER_44_491 VDD VSS sg13g2_decap_8
X_3931_ VSS VDD _3939_/C _3939_/D _3931_/Y _3935_/B sg13g2_a21oi_1
XFILLER_32_653 VDD VSS sg13g2_fill_1
X_3862_ input6/X hold857/X _3863_/S _4798_/D VDD VSS sg13g2_mux2_1
XFILLER_31_163 VDD VSS sg13g2_decap_8
X_2813_ _2813_/A _2813_/B _4921_/D VDD VSS sg13g2_nor2_1
X_3793_ _4760_/Q _3814_/A _3793_/Y VDD VSS sg13g2_nor2b_1
XFILLER_68_0 VDD VSS sg13g2_decap_8
X_2744_ _2748_/C _2743_/Y _4950_/D VDD VSS sg13g2_nor2b_1
XFILLER_106_909 VDD VSS sg13g2_decap_8
X_2675_ VSS VDD _2677_/A _4713_/Q _2675_/Y _2678_/A sg13g2_a21oi_1
XFILLER_114_920 VDD VSS sg13g2_decap_4
X_4414_ _4414_/RESET_B VSS VDD _4414_/D _4414_/Q clkload9/A sg13g2_dfrbpq_1
Xfanout305 fanout337/X fanout305/X VDD VSS sg13g2_buf_1
X_4345_ _4345_/RESET_B VSS VDD _4345_/D _4345_/Q _4964_/CLK sg13g2_dfrbpq_1
XFILLER_99_642 VDD VSS sg13g2_decap_8
Xfanout316 fanout317/X fanout316/X VDD VSS sg13g2_buf_1
Xfanout327 fanout336/X fanout327/X VDD VSS sg13g2_buf_1
XFILLER_99_697 VDD VSS sg13g2_decap_8
XFILLER_98_174 VDD VSS sg13g2_fill_1
XFILLER_98_141 VDD VSS sg13g2_decap_8
XFILLER_100_102 VDD VSS sg13g2_decap_8
X_4276_ _4276_/RESET_B VSS VDD _4276_/D _4276_/Q _4972_/CLK sg13g2_dfrbpq_1
X_4274__452 VDD VSS _4274_/RESET_B sg13g2_tiehi
XFILLER_28_904 VDD VSS sg13g2_decap_8
XFILLER_39_241 VDD VSS sg13g2_decap_4
X_3227_ VSS VDD _3229_/B _3226_/Y _3227_/Y _2604_/A sg13g2_a21oi_1
XFILLER_100_179 VDD VSS sg13g2_decap_8
XFILLER_27_403 VDD VSS sg13g2_decap_8
XFILLER_39_274 VDD VSS sg13g2_decap_8
XFILLER_67_594 VDD VSS sg13g2_decap_8
X_3158_ _3158_/Y _3158_/A _3158_/B VDD VSS sg13g2_xnor2_1
XFILLER_27_458 VDD VSS sg13g2_decap_4
XFILLER_55_756 VDD VSS sg13g2_fill_2
XFILLER_55_767 VDD VSS sg13g2_decap_8
XFILLER_70_737 VDD VSS sg13g2_decap_4
XFILLER_82_597 VDD VSS sg13g2_decap_8
X_3089_ _3089_/A0 _3114_/A1 _3109_/S _3089_/X VDD VSS sg13g2_mux2_1
XFILLER_23_631 VDD VSS sg13g2_fill_2
XFILLER_54_299 VDD VSS sg13g2_decap_8
XFILLER_70_759 VDD VSS sg13g2_decap_8
XFILLER_22_185 VDD VSS sg13g2_decap_8
XFILLER_23_686 VDD VSS sg13g2_decap_8
XFILLER_50_472 VDD VSS sg13g2_fill_2
XFILLER_50_483 VDD VSS sg13g2_decap_8
XFILLER_109_714 VDD VSS sg13g2_decap_8
X_4281__445 VDD VSS _4281_/RESET_B sg13g2_tiehi
XFILLER_105_920 VDD VSS sg13g2_decap_4
XFILLER_2_524 VDD VSS sg13g2_decap_4
XFILLER_2_546 VDD VSS sg13g2_decap_8
XFILLER_104_485 VDD VSS sg13g2_decap_8
XFILLER_78_848 VDD VSS sg13g2_decap_4
XFILLER_93_829 VDD VSS sg13g2_decap_8
XFILLER_92_306 VDD VSS sg13g2_decap_8
XFILLER_46_723 VDD VSS sg13g2_decap_8
XFILLER_58_572 VDD VSS sg13g2_fill_1
XFILLER_58_594 VDD VSS sg13g2_decap_8
XFILLER_73_520 VDD VSS sg13g2_decap_8
XFILLER_85_380 VDD VSS sg13g2_decap_8
XFILLER_93_22 VDD VSS sg13g2_decap_4
XFILLER_46_778 VDD VSS sg13g2_fill_2
XFILLER_73_542 VDD VSS sg13g2_decap_8
Xhold1070 _3001_/X VDD VSS _4428_/D sg13g2_dlygate4sd3_1
Xhold1081 _3444_/Y VDD VSS _4659_/D sg13g2_dlygate4sd3_1
Xhold1092 _4465_/Q VDD VSS _3550_/A1 sg13g2_dlygate4sd3_1
XFILLER_93_44 VDD VSS sg13g2_decap_8
XFILLER_93_88 VDD VSS sg13g2_decap_8
XFILLER_45_299 VDD VSS sg13g2_fill_2
XFILLER_13_130 VDD VSS sg13g2_fill_2
XFILLER_13_185 VDD VSS sg13g2_fill_1
XFILLER_14_686 VDD VSS sg13g2_decap_8
XFILLER_9_156 VDD VSS sg13g2_decap_8
XFILLER_10_881 VDD VSS sg13g2_decap_8
XFILLER_61_7 VDD VSS sg13g2_decap_8
XFILLER_108_780 VDD VSS sg13g2_decap_8
XFILLER_114_216 VDD VSS sg13g2_decap_8
XFILLER_6_896 VDD VSS sg13g2_decap_8
X_2460_ _4951_/Q _4952_/Q _4954_/Q _2464_/B VDD VSS sg13g2_nor3_1
XFILLER_114_249 VDD VSS sg13g2_fill_2
XFILLER_111_923 VDD VSS sg13g2_fill_2
XFILLER_69_804 VDD VSS sg13g2_decap_8
X_4130_ _4130_/Y _4130_/B _4236_/B1 VDD VSS sg13g2_nand2b_1
X_2391_ _2391_/Y _2391_/A _3369_/S VDD VSS sg13g2_nand2_1
XFILLER_110_433 VDD VSS sg13g2_decap_8
XFILLER_3_42 VDD VSS sg13g2_decap_8
XFILLER_68_325 VDD VSS sg13g2_decap_8
XFILLER_96_656 VDD VSS sg13g2_decap_8
XFILLER_1_590 VDD VSS sg13g2_decap_8
XFILLER_84_829 VDD VSS sg13g2_fill_1
X_4061_ _4232_/B1 VDD _4061_/Y VSS _4205_/A1 _4441_/Q sg13g2_o21ai_1
XFILLER_37_723 VDD VSS sg13g2_decap_8
XFILLER_64_520 VDD VSS sg13g2_decap_8
XFILLER_83_328 VDD VSS sg13g2_decap_4
X_3012_ _4030_/A2 _3012_/A1 _3029_/S _4438_/D VDD VSS sg13g2_mux2_1
XFILLER_76_380 VDD VSS sg13g2_decap_8
XFILLER_24_406 VDD VSS sg13g2_decap_8
XFILLER_51_203 VDD VSS sg13g2_decap_4
XFILLER_91_361 VDD VSS sg13g2_decap_8
XFILLER_24_439 VDD VSS sg13g2_decap_8
XFILLER_64_597 VDD VSS sg13g2_decap_8
X_4963_ _2849_/C VSS VDD _4963_/D _4963_/Q _4965_/CLK sg13g2_dfrbpq_1
X_4449__477 VDD VSS _4449_/RESET_B sg13g2_tiehi
X_3914_ VSS VDD _3939_/C _3912_/B _4812_/D hold712/X sg13g2_a21oi_1
XFILLER_20_612 VDD VSS sg13g2_decap_4
XFILLER_20_634 VDD VSS sg13g2_decap_8
X_4894_ fanout311/X VSS VDD _4894_/D _4894_/Q _4894_/CLK sg13g2_dfrbpq_1
X_3845_ _3845_/Y _3848_/A _3845_/B VDD VSS sg13g2_nand2_1
X_3776_ _3774_/Y VDD _3776_/Y VSS _3786_/B _3775_/Y sg13g2_o21ai_1
X_2727_ _2727_/A _2727_/B _2729_/B VDD VSS sg13g2_and2_1
X_2658_ _2660_/B _2677_/A _4707_/Q VDD VSS sg13g2_nand2_1
Xfanout102 fanout99/A _2896_/S VDD VSS sg13g2_buf_1
Xfanout113 _2823_/Y fanout113/X VDD VSS sg13g2_buf_1
X_2589_ _3195_/A _4582_/Q _2589_/C _3200_/A _3202_/B VDD VSS sg13g2_nor4_1
XFILLER_59_314 VDD VSS sg13g2_decap_8
Xfanout124 _3677_/B _3726_/B VDD VSS sg13g2_buf_1
Xfanout135 _4188_/B1 _4253_/A1 VDD VSS sg13g2_buf_1
Xfanout146 _3615_/A _3555_/A VDD VSS sg13g2_buf_1
X_4328_ _4328_/RESET_B VSS VDD _4328_/D _4328_/Q _4527_/CLK sg13g2_dfrbpq_1
XFILLER_74_306 VDD VSS sg13g2_decap_8
Xfanout157 _4245_/B1 _4147_/B1 VDD VSS sg13g2_buf_1
Xfanout168 fanout170/X _3977_/S VDD VSS sg13g2_buf_1
Xfanout179 _4827_/Q _4254_/A1 VDD VSS sg13g2_buf_1
X_4259_ fanout279/X VSS VDD _4259_/D _4259_/Q _4942_/CLK sg13g2_dfrbpq_1
XFILLER_86_144 VDD VSS sg13g2_decap_4
XFILLER_28_723 VDD VSS sg13g2_decap_8
XFILLER_68_870 VDD VSS sg13g2_fill_1
XFILLER_86_199 VDD VSS sg13g2_fill_1
XFILLER_103_21 VDD VSS sg13g2_decap_8
XFILLER_16_907 VDD VSS sg13g2_decap_8
XFILLER_55_575 VDD VSS sg13g2_decap_8
XFILLER_63_14 VDD VSS sg13g2_decap_8
XFILLER_27_288 VDD VSS sg13g2_decap_8
XFILLER_27_299 VDD VSS sg13g2_fill_2
XFILLER_42_236 VDD VSS sg13g2_decap_8
XFILLER_70_534 VDD VSS sg13g2_decap_8
XFILLER_82_383 VDD VSS sg13g2_decap_4
XFILLER_23_461 VDD VSS sg13g2_decap_8
XFILLER_10_122 VDD VSS sg13g2_decap_8
XFILLER_7_605 VDD VSS sg13g2_decap_8
XFILLER_109_500 VDD VSS sg13g2_fill_1
XFILLER_10_199 VDD VSS sg13g2_decap_8
XFILLER_3_800 VDD VSS sg13g2_decap_8
XFILLER_88_44 VDD VSS sg13g2_fill_2
XFILLER_3_877 VDD VSS sg13g2_decap_8
XFILLER_88_66 VDD VSS sg13g2_decap_4
XFILLER_104_260 VDD VSS sg13g2_decap_8
XFILLER_78_667 VDD VSS sg13g2_fill_1
XFILLER_18_200 VDD VSS sg13g2_decap_4
XFILLER_59_881 VDD VSS sg13g2_fill_1
XFILLER_77_166 VDD VSS sg13g2_decap_8
XFILLER_92_103 VDD VSS sg13g2_decap_8
XFILLER_19_767 VDD VSS sg13g2_decap_8
XFILLER_37_70 VDD VSS sg13g2_decap_8
XFILLER_61_512 VDD VSS sg13g2_fill_2
XFILLER_34_737 VDD VSS sg13g2_decap_8
XFILLER_34_748 VDD VSS sg13g2_fill_2
XFILLER_34_759 VDD VSS sg13g2_decap_4
XFILLER_14_450 VDD VSS sg13g2_decap_8
XFILLER_33_269 VDD VSS sg13g2_fill_1
XFILLER_30_921 VDD VSS sg13g2_decap_4
X_4264__462 VDD VSS _4264_/RESET_B sg13g2_tiehi
X_3630_ _3694_/A _3718_/A _3664_/A VDD VSS sg13g2_nor2_1
X_3561_ _3561_/Y _3563_/A _3601_/B VDD VSS sg13g2_nand2_1
X_2512_ _3176_/A _2512_/B _3176_/B _3181_/B VDD VSS sg13g2_or3_1
XFILLER_115_558 VDD VSS sg13g2_decap_8
XFILLER_5_170 VDD VSS sg13g2_decap_8
X_3492_ _3491_/Y VDD _3493_/C VSS _4902_/Q _3378_/B sg13g2_o21ai_1
X_2443_ _2442_/X VDD _2443_/Y VSS _2432_/C _2431_/Y sg13g2_o21ai_1
XFILLER_111_731 VDD VSS sg13g2_decap_4
X_2374_ _2387_/C _4682_/Q _4674_/Q _4667_/Q _4675_/Q VDD VSS sg13g2_a22oi_1
XFILLER_29_509 VDD VSS sg13g2_decap_8
XFILLER_69_678 VDD VSS sg13g2_fill_1
X_4113_ _4421_/Q _4446_/Q _4118_/S _4113_/X VDD VSS sg13g2_mux2_1
XFILLER_57_829 VDD VSS sg13g2_decap_4
XFILLER_68_188 VDD VSS sg13g2_decap_8
XFILLER_37_520 VDD VSS sg13g2_decap_8
XFILLER_65_851 VDD VSS sg13g2_decap_4
XFILLER_84_659 VDD VSS sg13g2_decap_8
X_4271__455 VDD VSS _4271_/RESET_B sg13g2_tiehi
X_4044_ _4044_/Y _4044_/B _4227_/B1 VDD VSS sg13g2_nand2b_1
XFILLER_25_726 VDD VSS sg13g2_decap_8
XFILLER_65_862 VDD VSS sg13g2_decap_8
XFILLER_37_597 VDD VSS sg13g2_decap_8
XFILLER_80_876 VDD VSS sg13g2_decap_4
XFILLER_21_910 VDD VSS sg13g2_decap_8
XFILLER_33_781 VDD VSS sg13g2_fill_2
X_4946_ fanout279/X VSS VDD _4946_/D _4946_/Q _4946_/CLK sg13g2_dfrbpq_1
X_4877_ fanout304/X VSS VDD _4877_/D _4877_/Q _4877_/CLK sg13g2_dfrbpq_1
X_3828_ _3828_/Y _3837_/B1 _3827_/Y _3828_/A2 _3415_/A VDD VSS sg13g2_a22oi_1
X_3759_ _4765_/Q _3764_/D _3832_/A _3765_/B VDD VSS sg13g2_nand3_1
XFILLER_109_7 VDD VSS sg13g2_decap_8
XFILLER_79_409 VDD VSS sg13g2_decap_4
XFILLER_114_591 VDD VSS sg13g2_fill_2
XFILLER_58_14 VDD VSS sg13g2_decap_8
XFILLER_58_47 VDD VSS sg13g2_decap_8
XFILLER_0_858 VDD VSS sg13g2_decap_8
XFILLER_102_742 VDD VSS sg13g2_decap_8
XFILLER_59_144 VDD VSS sg13g2_decap_8
XFILLER_47_328 VDD VSS sg13g2_decap_8
XFILLER_48_829 VDD VSS sg13g2_decap_8
XFILLER_56_851 VDD VSS sg13g2_decap_8
XFILLER_75_659 VDD VSS sg13g2_decap_8
XFILLER_16_715 VDD VSS sg13g2_fill_1
XFILLER_28_564 VDD VSS sg13g2_decap_8
XFILLER_43_501 VDD VSS sg13g2_decap_8
XFILLER_74_158 VDD VSS sg13g2_fill_1
XFILLER_83_670 VDD VSS sg13g2_decap_8
XFILLER_15_225 VDD VSS sg13g2_decap_8
XFILLER_55_372 VDD VSS sg13g2_decap_8
X_4387__339 VDD VSS _4387_/RESET_B sg13g2_tiehi
XFILLER_70_353 VDD VSS sg13g2_decap_8
XFILLER_71_865 VDD VSS sg13g2_fill_2
XFILLER_71_876 VDD VSS sg13g2_fill_1
XFILLER_11_431 VDD VSS sg13g2_fill_2
XFILLER_11_475 VDD VSS sg13g2_decap_8
XFILLER_7_424 VDD VSS sg13g2_decap_8
XFILLER_8_925 VDD VSS sg13g2_fill_1
XFILLER_109_352 VDD VSS sg13g2_decap_8
XFILLER_99_65 VDD VSS sg13g2_fill_1
XFILLER_112_506 VDD VSS sg13g2_fill_2
XFILLER_2_140 VDD VSS sg13g2_decap_4
X_4439__487 VDD VSS _4439_/RESET_B sg13g2_tiehi
XFILLER_24_7 VDD VSS sg13g2_decap_8
XFILLER_38_317 VDD VSS sg13g2_decap_8
XFILLER_78_475 VDD VSS sg13g2_decap_8
XFILLER_94_924 VDD VSS sg13g2_fill_2
XFILLER_93_423 VDD VSS sg13g2_decap_8
XFILLER_19_520 VDD VSS sg13g2_decap_8
XFILLER_47_851 VDD VSS sg13g2_decap_8
XFILLER_48_80 VDD VSS sg13g2_decap_8
XFILLER_66_659 VDD VSS sg13g2_decap_8
XFILLER_0_21 VDD VSS sg13g2_decap_8
XFILLER_65_169 VDD VSS sg13g2_decap_4
XFILLER_0_98 VDD VSS sg13g2_decap_8
XFILLER_62_865 VDD VSS sg13g2_decap_8
X_4800_ fanout292/X VSS VDD _4800_/D _4800_/Q _4807_/CLK sg13g2_dfrbpq_1
XFILLER_15_781 VDD VSS sg13g2_decap_8
XFILLER_61_364 VDD VSS sg13g2_decap_8
X_2992_ _2992_/A0 _3094_/A0 _3008_/S _2992_/X VDD VSS sg13g2_mux2_1
X_4731_ fanout287/X VSS VDD _4731_/D _4731_/Q _4737_/CLK sg13g2_dfrbpq_1
XFILLER_30_751 VDD VSS sg13g2_decap_8
XFILLER_30_773 VDD VSS sg13g2_decap_8
X_4662_ fanout253/X VSS VDD _4662_/D _4662_/Q _4673_/CLK sg13g2_dfrbpq_1
X_3613_ _3610_/Y VDD _3613_/Y VSS _3568_/B _3612_/Y sg13g2_o21ai_1
Xhold903 _3018_/X VDD VSS _4444_/D sg13g2_dlygate4sd3_1
X_4593_ fanout289/X VSS VDD _4593_/D _4593_/Q _4807_/CLK sg13g2_dfrbpq_1
XFILLER_116_845 VDD VSS sg13g2_decap_8
XFILLER_50_0 VDD VSS sg13g2_decap_8
Xhold925 _4439_/Q VDD VSS hold925/X sg13g2_dlygate4sd3_1
Xhold936 _4374_/Q VDD VSS hold936/X sg13g2_dlygate4sd3_1
Xhold914 _4505_/Q VDD VSS hold914/X sg13g2_dlygate4sd3_1
X_3544_ _4706_/Q _3544_/A1 _3552_/S _3544_/X VDD VSS sg13g2_mux2_1
Xhold947 _3120_/X VDD VSS _4544_/D sg13g2_dlygate4sd3_1
Xhold958 _4817_/Q VDD VSS _3935_/A sg13g2_dlygate4sd3_1
Xhold969 _4394_/Q VDD VSS hold969/X sg13g2_dlygate4sd3_1
X_3475_ _3489_/B _3475_/C _3475_/A _3475_/Y VDD VSS sg13g2_nand3_1
XFILLER_115_399 VDD VSS sg13g2_fill_1
X_2426_ _2426_/B _2809_/A _2426_/Y VDD VSS _2422_/C sg13g2_nand3b_1
XFILLER_88_228 VDD VSS sg13g2_decap_8
XFILLER_111_583 VDD VSS sg13g2_decap_8
XFILLER_29_317 VDD VSS sg13g2_decap_8
Xhold1603 _4764_/Q VDD VSS _3751_/B sg13g2_dlygate4sd3_1
Xhold1614 _2642_/Y VDD VSS _4855_/D sg13g2_dlygate4sd3_1
Xhold1625 _4725_/Q VDD VSS _3599_/A sg13g2_dlygate4sd3_1
X_2357_ VDD _2412_/C _2357_/A VSS sg13g2_inv_1
XFILLER_97_773 VDD VSS sg13g2_fill_1
XFILLER_85_924 VDD VSS sg13g2_fill_2
XFILLER_85_913 VDD VSS sg13g2_decap_8
XFILLER_56_147 VDD VSS sg13g2_decap_8
XFILLER_57_648 VDD VSS sg13g2_decap_8
XFILLER_84_445 VDD VSS sg13g2_decap_8
Xhold1636 _4688_/Q VDD VSS _2333_/A sg13g2_dlygate4sd3_1
Xhold1647 _4617_/Q VDD VSS _2616_/B sg13g2_dlygate4sd3_1
Xhold1658 _3828_/Y VDD VSS _4783_/D sg13g2_dlygate4sd3_1
Xhold1669 _4786_/Q VDD VSS hold1669/X sg13g2_dlygate4sd3_1
X_2288_ VDD _2288_/Y _3467_/A VSS sg13g2_inv_1
XFILLER_72_629 VDD VSS sg13g2_fill_1
XFILLER_84_478 VDD VSS sg13g2_decap_8
X_4027_ _4026_/Y VDD _4027_/Y VSS _4023_/Y _4025_/Y sg13g2_o21ai_1
XFILLER_53_821 VDD VSS sg13g2_decap_4
XFILLER_71_117 VDD VSS sg13g2_decap_8
XFILLER_44_49 VDD VSS sg13g2_fill_1
XFILLER_53_876 VDD VSS sg13g2_fill_1
XFILLER_13_718 VDD VSS sg13g2_decap_4
X_4929_ fanout316/X VSS VDD _4929_/D _4929_/Q _4929_/CLK sg13g2_dfrbpq_1
XFILLER_21_784 VDD VSS sg13g2_fill_1
XFILLER_4_416 VDD VSS sg13g2_decap_8
XFILLER_109_64 VDD VSS sg13g2_decap_8
XFILLER_107_867 VDD VSS sg13g2_decap_8
XFILLER_0_655 VDD VSS sg13g2_decap_8
XFILLER_76_913 VDD VSS sg13g2_decap_8
XFILLER_76_924 VDD VSS sg13g2_fill_2
XFILLER_102_594 VDD VSS sg13g2_decap_8
XFILLER_29_840 VDD VSS sg13g2_decap_8
XFILLER_75_434 VDD VSS sg13g2_decap_8
XFILLER_28_372 VDD VSS sg13g2_fill_2
XFILLER_44_832 VDD VSS sg13g2_decap_8
XFILLER_56_692 VDD VSS sg13g2_decap_8
XFILLER_16_545 VDD VSS sg13g2_decap_4
XFILLER_31_515 VDD VSS sg13g2_decap_8
XFILLER_8_722 VDD VSS sg13g2_fill_1
XFILLER_116_119 VDD VSS sg13g2_decap_8
XFILLER_7_298 VDD VSS sg13g2_decap_8
X_4261__465 VDD VSS _4261_/RESET_B sg13g2_tiehi
XFILLER_3_471 VDD VSS sg13g2_decap_4
X_3260_ _2611_/B VDD _3260_/Y VSS _3258_/A _3258_/B sg13g2_o21ai_1
XFILLER_38_103 VDD VSS sg13g2_fill_1
XFILLER_67_924 VDD VSS sg13g2_fill_2
XFILLER_78_250 VDD VSS sg13g2_decap_8
XFILLER_79_784 VDD VSS sg13g2_decap_4
X_3191_ _3145_/B VDD _3191_/Y VSS _2260_/Y _3189_/A sg13g2_o21ai_1
XFILLER_66_434 VDD VSS sg13g2_decap_8
XFILLER_94_765 VDD VSS sg13g2_decap_8
XFILLER_19_361 VDD VSS sg13g2_decap_8
XFILLER_35_821 VDD VSS sg13g2_decap_8
XFILLER_35_854 VDD VSS sg13g2_decap_8
XFILLER_22_559 VDD VSS sg13g2_decap_8
XFILLER_50_857 VDD VSS sg13g2_decap_8
XFILLER_61_172 VDD VSS sg13g2_decap_8
X_4714_ fanout305/X VSS VDD _4714_/D _4714_/Q _4974_/CLK sg13g2_dfrbpq_1
X_2975_ hold865/X _3104_/A0 _2975_/S _4404_/D VDD VSS sg13g2_mux2_1
XFILLER_30_581 VDD VSS sg13g2_decap_8
X_4645_ fanout253/X VSS VDD _4645_/D _4645_/Q _4673_/CLK sg13g2_dfrbpq_1
Xhold711 _4812_/Q VDD VSS _3918_/B sg13g2_dlygate4sd3_1
Xhold700 _2579_/Y VDD VSS _2581_/A sg13g2_dlygate4sd3_1
X_4576_ fanout330/X VSS VDD _4576_/D _4576_/Q _4580_/CLK sg13g2_dfrbpq_1
XFILLER_1_408 VDD VSS sg13g2_decap_8
Xhold755 _3693_/Y VDD VSS _4751_/D sg13g2_dlygate4sd3_1
Xhold744 _3273_/Y VDD VSS hold744/X sg13g2_dlygate4sd3_1
Xhold733 _3233_/Y VDD VSS _4598_/D sg13g2_dlygate4sd3_1
Xhold722 _4818_/Q VDD VSS _3935_/C sg13g2_dlygate4sd3_1
X_3527_ _4690_/D _3527_/B _3556_/B VDD VSS sg13g2_nand2b_1
XFILLER_115_185 VDD VSS sg13g2_fill_1
Xhold788 _4259_/Q VDD VSS hold788/X sg13g2_dlygate4sd3_1
Xhold777 _3454_/Y VDD VSS _4664_/D sg13g2_dlygate4sd3_1
Xhold766 _3942_/Y VDD VSS _4819_/D sg13g2_dlygate4sd3_1
X_4377__349 VDD VSS _4377_/RESET_B sg13g2_tiehi
XFILLER_103_347 VDD VSS sg13g2_fill_1
XFILLER_39_16 VDD VSS sg13g2_fill_1
XFILLER_39_27 VDD VSS sg13g2_decap_4
Xhold799 _4801_/Q VDD VSS _2473_/B sg13g2_dlygate4sd3_1
X_3458_ _3457_/Y VDD _4666_/D VSS _2275_/Y _3475_/C sg13g2_o21ai_1
XFILLER_76_209 VDD VSS sg13g2_decap_8
Xhold1400 _4581_/Q VDD VSS _3195_/A sg13g2_dlygate4sd3_1
X_3389_ _3390_/C _4902_/Q _3424_/A VDD VSS sg13g2_nand2_1
X_2409_ _3407_/A _2411_/D _2807_/B VDD VSS sg13g2_nor2_1
XFILLER_57_445 VDD VSS sg13g2_decap_8
XFILLER_84_220 VDD VSS sg13g2_decap_8
Xhold1411 _3575_/Y VDD VSS _3576_/C sg13g2_dlygate4sd3_1
Xhold1422 _3288_/Y VDD VSS _3289_/B sg13g2_dlygate4sd3_1
Xhold1433 _4591_/Q VDD VSS _3215_/A sg13g2_dlygate4sd3_1
XFILLER_97_581 VDD VSS sg13g2_decap_8
XFILLER_29_169 VDD VSS sg13g2_decap_4
XFILLER_45_607 VDD VSS sg13g2_decap_8
XFILLER_45_618 VDD VSS sg13g2_fill_1
Xhold1444 _4749_/Q VDD VSS _3654_/A0 sg13g2_dlygate4sd3_1
Xhold1455 _4811_/Q VDD VSS _3907_/A sg13g2_dlygate4sd3_1
Xhold1466 _3200_/Y VDD VSS _3201_/A2 sg13g2_dlygate4sd3_1
Xhold1477 _3249_/Y VDD VSS _3250_/A2 sg13g2_dlygate4sd3_1
XFILLER_84_286 VDD VSS sg13g2_fill_1
Xhold1488 _4640_/Q VDD VSS _3646_/A sg13g2_dlygate4sd3_1
Xhold1499 _3786_/Y VDD VSS _3787_/B1 sg13g2_dlygate4sd3_1
XFILLER_111_21 VDD VSS sg13g2_decap_8
XFILLER_53_640 VDD VSS sg13g2_decap_8
XFILLER_41_813 VDD VSS sg13g2_fill_2
XFILLER_40_334 VDD VSS sg13g2_decap_8
XFILLER_71_14 VDD VSS sg13g2_decap_4
XFILLER_71_58 VDD VSS sg13g2_decap_4
X_4429__497 VDD VSS _4429_/RESET_B sg13g2_tiehi
XFILLER_21_570 VDD VSS sg13g2_decap_8
XFILLER_107_620 VDD VSS sg13g2_decap_8
XFILLER_4_213 VDD VSS sg13g2_fill_1
XFILLER_5_725 VDD VSS sg13g2_decap_8
XFILLER_4_268 VDD VSS sg13g2_decap_8
XFILLER_106_196 VDD VSS sg13g2_decap_8
XFILLER_0_452 VDD VSS sg13g2_decap_8
XFILLER_103_870 VDD VSS sg13g2_decap_4
XFILLER_103_881 VDD VSS sg13g2_fill_1
XFILLER_49_913 VDD VSS sg13g2_decap_8
XFILLER_49_924 VDD VSS sg13g2_fill_2
XFILLER_102_391 VDD VSS sg13g2_fill_1
XFILLER_29_60 VDD VSS sg13g2_decap_8
XFILLER_48_434 VDD VSS sg13g2_decap_8
XFILLER_76_787 VDD VSS sg13g2_decap_8
XFILLER_63_437 VDD VSS sg13g2_decap_8
XFILLER_75_286 VDD VSS sg13g2_decap_8
XFILLER_91_757 VDD VSS sg13g2_decap_8
XFILLER_16_353 VDD VSS sg13g2_decap_8
XFILLER_44_673 VDD VSS sg13g2_decap_8
XFILLER_31_323 VDD VSS sg13g2_decap_8
XFILLER_91_7 VDD VSS sg13g2_decap_8
Xclkbuf_4_14_0_clk clkbuf_0_clk/X clkbuf_4_14_0_clk/X VDD VSS sg13g2_buf_8
X_2760_ _2766_/B _2760_/B _2762_/C VDD VSS sg13g2_nor2_1
XFILLER_61_91 VDD VSS sg13g2_decap_8
X_2691_ _4861_/Q _2691_/C _3555_/A _2696_/B VDD VSS sg13g2_nand3_1
X_4430_ _4430_/RESET_B VSS VDD _4430_/D _4430_/Q _4974_/CLK sg13g2_dfrbpq_1
XFILLER_6_64 VDD VSS sg13g2_decap_8
X_4361_ _4361_/RESET_B VSS VDD _4361_/D _4361_/Q _4729_/CLK sg13g2_dfrbpq_1
XFILLER_113_645 VDD VSS sg13g2_decap_8
X_4292_ _4292_/RESET_B VSS VDD _4292_/D _4292_/Q _4973_/CLK sg13g2_dfrbpq_1
X_3312_ _3312_/Y _4787_/Q _4785_/Q VDD VSS sg13g2_nand2_1
XFILLER_100_306 VDD VSS sg13g2_decap_8
XFILLER_67_710 VDD VSS sg13g2_decap_8
X_3243_ _4602_/D _3278_/A _3243_/B VDD VSS sg13g2_nand2_1
XFILLER_13_0 VDD VSS sg13g2_decap_8
XFILLER_39_478 VDD VSS sg13g2_fill_1
X_3174_ _3174_/Y _3174_/A _3174_/B VDD VSS sg13g2_xnor2_1
XFILLER_54_404 VDD VSS sg13g2_decap_8
XFILLER_34_161 VDD VSS sg13g2_decap_8
XFILLER_41_109 VDD VSS sg13g2_decap_8
XFILLER_50_610 VDD VSS sg13g2_fill_2
XFILLER_81_267 VDD VSS sg13g2_fill_1
XFILLER_50_632 VDD VSS sg13g2_decap_8
XFILLER_22_356 VDD VSS sg13g2_fill_1
XFILLER_23_868 VDD VSS sg13g2_decap_4
XFILLER_50_687 VDD VSS sg13g2_decap_8
X_2958_ _2958_/A0 _3087_/A0 _2981_/S _4387_/D VDD VSS sg13g2_mux2_1
XFILLER_108_417 VDD VSS sg13g2_decap_8
X_4628_ fanout266/X VSS VDD _4628_/D _4628_/Q _4658_/CLK sg13g2_dfrbpq_1
X_2889_ hold909/X _3021_/A1 _2900_/S _2889_/X VDD VSS sg13g2_mux2_1
XFILLER_116_450 VDD VSS sg13g2_decap_8
XFILLER_116_461 VDD VSS sg13g2_fill_1
Xhold541 _2501_/Y VDD VSS _4900_/D sg13g2_dlygate4sd3_1
Xhold552 _4859_/Q VDD VSS _3556_/A sg13g2_dlygate4sd3_1
Xhold563 _4843_/Q VDD VSS _2721_/C sg13g2_dlygate4sd3_1
X_4559_ fanout287/X VSS VDD _4559_/D _4559_/Q _4559_/CLK sg13g2_dfrbpq_1
XFILLER_103_133 VDD VSS sg13g2_fill_1
Xhold574 _4556_/Q VDD VSS _3136_/A sg13g2_dlygate4sd3_1
Xhold585 _4888_/Q VDD VSS _2571_/B sg13g2_dlygate4sd3_1
Xhold596 _3990_/Y VDD VSS _4834_/D sg13g2_dlygate4sd3_1
XFILLER_89_345 VDD VSS sg13g2_decap_8
XFILLER_104_689 VDD VSS sg13g2_decap_8
XFILLER_66_14 VDD VSS sg13g2_decap_8
XFILLER_100_840 VDD VSS sg13g2_decap_8
XFILLER_57_242 VDD VSS sg13g2_fill_1
Xhold1230 _3917_/Y VDD VSS _4813_/D sg13g2_dlygate4sd3_1
Xhold1241 _2928_/X VDD VSS _4360_/D sg13g2_dlygate4sd3_1
Xhold1252 _2909_/X VDD VSS _4341_/D sg13g2_dlygate4sd3_1
XFILLER_85_540 VDD VSS sg13g2_decap_8
XFILLER_17_106 VDD VSS sg13g2_decap_8
XFILLER_73_713 VDD VSS sg13g2_decap_8
XFILLER_73_724 VDD VSS sg13g2_fill_1
Xhold1263 _4474_/Q VDD VSS _3535_/A1 sg13g2_dlygate4sd3_1
Xhold1274 _4698_/Q VDD VSS _3536_/A0 sg13g2_dlygate4sd3_1
Xhold1285 _4686_/Q VDD VSS _2654_/A sg13g2_dlygate4sd3_1
XFILLER_61_908 VDD VSS sg13g2_fill_1
Xhold1296 _4336_/Q VDD VSS _2904_/A0 sg13g2_dlygate4sd3_1
XFILLER_13_334 VDD VSS sg13g2_decap_8
XFILLER_82_68 VDD VSS sg13g2_decap_8
XFILLER_14_879 VDD VSS sg13g2_decap_8
XFILLER_15_73 VDD VSS sg13g2_decap_8
XFILLER_41_676 VDD VSS sg13g2_decap_8
XFILLER_31_72 VDD VSS sg13g2_decap_4
XFILLER_96_805 VDD VSS sg13g2_decap_8
XFILLER_1_761 VDD VSS sg13g2_decap_8
XFILLER_96_838 VDD VSS sg13g2_decap_4
XFILLER_96_849 VDD VSS sg13g2_decap_8
XFILLER_95_337 VDD VSS sg13g2_decap_4
XFILLER_36_426 VDD VSS sg13g2_fill_2
XFILLER_48_286 VDD VSS sg13g2_decap_8
XFILLER_56_91 VDD VSS sg13g2_decap_8
XFILLER_64_746 VDD VSS sg13g2_decap_8
XFILLER_91_554 VDD VSS sg13g2_decap_8
X_3930_ _3930_/A _3930_/B _3932_/A VDD VSS sg13g2_nor2_1
X_4367__359 VDD VSS _4367_/RESET_B sg13g2_tiehi
XFILLER_31_142 VDD VSS sg13g2_decap_8
X_3861_ input5/X hold838/X _3863_/S _4797_/D VDD VSS sg13g2_mux2_1
XFILLER_20_849 VDD VSS sg13g2_decap_8
X_3792_ _4759_/Q _3792_/B _4758_/Q _3814_/A VDD VSS sg13g2_nor3_1
X_2812_ _2812_/B _2812_/A _2812_/X VDD VSS sg13g2_xor2_1
X_2743_ VSS VDD _2742_/A _2742_/B _2743_/Y _2749_/A sg13g2_a21oi_1
XFILLER_8_371 VDD VSS sg13g2_decap_8
X_2674_ _2674_/Y _4712_/Q _2677_/A VDD VSS sg13g2_nand2b_1
X_4413_ _4413_/RESET_B VSS VDD _4413_/D _4413_/Q _4926_/CLK sg13g2_dfrbpq_1
XFILLER_99_621 VDD VSS sg13g2_decap_8
X_4344_ _4344_/RESET_B VSS VDD _4344_/D _4344_/Q _4817_/CLK sg13g2_dfrbpq_1
Xfanout306 fanout311/X fanout306/X VDD VSS sg13g2_buf_1
Xfanout317 fanout319/X fanout317/X VDD VSS sg13g2_buf_1
Xfanout328 fanout331/X fanout328/X VDD VSS sg13g2_buf_1
X_4275_ _4275_/RESET_B VSS VDD _4275_/D _4275_/Q _4397_/CLK sg13g2_dfrbpq_1
XFILLER_87_849 VDD VSS sg13g2_decap_8
XFILLER_100_158 VDD VSS sg13g2_decap_8
X_3226_ _2598_/B VDD _3226_/Y VSS _3224_/A _3224_/B sg13g2_o21ai_1
XFILLER_54_212 VDD VSS sg13g2_decap_4
XFILLER_55_735 VDD VSS sg13g2_decap_8
X_3157_ _3184_/B VDD _3157_/Y VSS _3179_/B1 _3156_/X sg13g2_o21ai_1
XFILLER_54_278 VDD VSS sg13g2_decap_8
XFILLER_70_716 VDD VSS sg13g2_decap_8
X_3088_ _3088_/A0 hold904/X _3108_/S _4512_/D VDD VSS sg13g2_mux2_1
XFILLER_35_470 VDD VSS sg13g2_fill_2
XFILLER_22_142 VDD VSS sg13g2_decap_8
XFILLER_22_164 VDD VSS sg13g2_decap_8
XFILLER_52_49 VDD VSS sg13g2_decap_8
XFILLER_10_337 VDD VSS sg13g2_fill_2
XFILLER_108_258 VDD VSS sg13g2_decap_8
XFILLER_108_269 VDD VSS sg13g2_fill_2
XFILLER_116_291 VDD VSS sg13g2_decap_8
XFILLER_104_442 VDD VSS sg13g2_decap_8
XFILLER_104_464 VDD VSS sg13g2_decap_8
XFILLER_77_326 VDD VSS sg13g2_fill_2
XFILLER_89_197 VDD VSS sg13g2_decap_8
XFILLER_58_551 VDD VSS sg13g2_decap_8
XFILLER_77_359 VDD VSS sg13g2_decap_8
XFILLER_93_808 VDD VSS sg13g2_decap_8
Xhold1060 _2968_/X VDD VSS _4397_/D sg13g2_dlygate4sd3_1
Xhold1071 _4327_/Q VDD VSS _2894_/A0 sg13g2_dlygate4sd3_1
Xhold1082 _4318_/Q VDD VSS _2885_/A0 sg13g2_dlygate4sd3_1
Xhold1093 _3550_/X VDD VSS _4712_/D sg13g2_dlygate4sd3_1
XFILLER_26_50 VDD VSS sg13g2_fill_2
XFILLER_34_919 VDD VSS sg13g2_decap_8
XFILLER_73_576 VDD VSS sg13g2_fill_2
XFILLER_93_67 VDD VSS sg13g2_decap_8
XFILLER_14_654 VDD VSS sg13g2_decap_8
XFILLER_41_440 VDD VSS sg13g2_decap_8
XFILLER_41_473 VDD VSS sg13g2_decap_8
XFILLER_9_124 VDD VSS sg13g2_decap_4
XFILLER_10_860 VDD VSS sg13g2_decap_8
XFILLER_42_93 VDD VSS sg13g2_decap_8
XFILLER_54_7 VDD VSS sg13g2_decap_8
XFILLER_5_363 VDD VSS sg13g2_fill_2
XFILLER_6_875 VDD VSS sg13g2_decap_8
XFILLER_3_21 VDD VSS sg13g2_decap_8
X_2390_ _2391_/A _3369_/S _2819_/B VDD VSS sg13g2_and2_1
XFILLER_110_412 VDD VSS sg13g2_decap_8
XFILLER_68_315 VDD VSS sg13g2_decap_4
XFILLER_96_635 VDD VSS sg13g2_decap_8
XFILLER_84_808 VDD VSS sg13g2_decap_8
X_4060_ _4144_/S _4416_/Q _4060_/Y VDD VSS sg13g2_nor2_1
XFILLER_110_489 VDD VSS sg13g2_decap_8
XFILLER_37_702 VDD VSS sg13g2_decap_8
XFILLER_49_584 VDD VSS sg13g2_decap_8
XFILLER_77_871 VDD VSS sg13g2_decap_8
X_3011_ _3011_/A0 _3011_/A1 _3034_/S _4437_/D VDD VSS sg13g2_mux2_1
XFILLER_92_830 VDD VSS sg13g2_decap_8
XFILLER_64_576 VDD VSS sg13g2_decap_8
XFILLER_51_226 VDD VSS sg13g2_decap_8
XFILLER_51_237 VDD VSS sg13g2_fill_1
X_4962_ fanout296/X VSS VDD _4962_/D _4962_/Q _4968_/CLK sg13g2_dfrbpq_1
X_4893_ fanout311/X VSS VDD _4893_/D _4893_/Q _4894_/CLK sg13g2_dfrbpq_1
X_3913_ VSS VDD _3939_/C _3910_/B _3913_/Y _3918_/B sg13g2_a21oi_1
XFILLER_32_462 VDD VSS sg13g2_decap_4
X_3844_ _3845_/B _3844_/A _3844_/B VDD VSS sg13g2_xnor2_1
XFILLER_80_0 VDD VSS sg13g2_decap_8
X_3775_ _3775_/Y _3844_/A _3779_/C VDD VSS sg13g2_xnor2_1
X_2726_ _2727_/A _2727_/B _2728_/B VDD VSS sg13g2_nor2_1
X_2657_ _2677_/A _4700_/Q _4701_/Q _4702_/Q _4703_/Q _2678_/A _2657_/X VDD VSS sg13g2_mux4_1
Xfanout103 _2877_/Y fanout99/A VDD VSS sg13g2_buf_1
X_2588_ _3195_/A _4582_/Q _2589_/C _3200_/B VDD VSS sg13g2_nor3_1
XFILLER_99_440 VDD VSS sg13g2_decap_8
Xfanout114 _2756_/Y _3788_/B VDD VSS sg13g2_buf_1
Xfanout125 _2585_/Y _3145_/B VDD VSS sg13g2_buf_1
Xfanout136 _2347_/Y _4188_/B1 VDD VSS sg13g2_buf_1
Xfanout147 _3109_/S _3108_/S VDD VSS sg13g2_buf_1
X_4327_ _4327_/RESET_B VSS VDD _4327_/D _4327_/Q _4958_/CLK sg13g2_dfrbpq_1
XFILLER_99_495 VDD VSS sg13g2_decap_8
XFILLER_86_123 VDD VSS sg13g2_decap_8
XFILLER_101_434 VDD VSS sg13g2_decap_8
XFILLER_101_445 VDD VSS sg13g2_fill_1
Xfanout158 _4245_/B1 _4227_/B1 VDD VSS sg13g2_buf_1
Xfanout169 fanout170/X _4006_/B VDD VSS sg13g2_buf_1
X_4258_ _4258_/A _4898_/D VDD VSS sg13g2_buf_1
XFILLER_27_201 VDD VSS sg13g2_decap_8
XFILLER_28_713 VDD VSS sg13g2_fill_1
X_3209_ _3230_/A _3209_/B _4588_/D VDD VSS sg13g2_nor2_1
XFILLER_86_189 VDD VSS sg13g2_fill_2
XFILLER_86_167 VDD VSS sg13g2_fill_2
X_4189_ _4189_/B1 VDD _4189_/Y VSS _4187_/Y _4188_/Y sg13g2_o21ai_1
XFILLER_103_66 VDD VSS sg13g2_decap_8
XFILLER_27_267 VDD VSS sg13g2_decap_8
XFILLER_15_429 VDD VSS sg13g2_decap_8
XFILLER_43_749 VDD VSS sg13g2_fill_2
XFILLER_70_513 VDD VSS sg13g2_decap_8
XFILLER_82_373 VDD VSS sg13g2_fill_1
XFILLER_23_440 VDD VSS sg13g2_decap_8
XFILLER_10_101 VDD VSS sg13g2_decap_8
XFILLER_11_602 VDD VSS sg13g2_fill_1
XFILLER_51_793 VDD VSS sg13g2_fill_2
XFILLER_50_270 VDD VSS sg13g2_decap_8
XFILLER_11_679 VDD VSS sg13g2_decap_8
XFILLER_10_178 VDD VSS sg13g2_decap_8
XFILLER_6_127 VDD VSS sg13g2_decap_8
XFILLER_109_578 VDD VSS sg13g2_decap_4
XFILLER_12_74 VDD VSS sg13g2_decap_8
XFILLER_3_856 VDD VSS sg13g2_decap_8
XFILLER_78_646 VDD VSS sg13g2_decap_8
X_4357__369 VDD VSS _4357_/RESET_B sg13g2_tiehi
XFILLER_77_145 VDD VSS sg13g2_decap_8
XFILLER_93_605 VDD VSS sg13g2_decap_4
XFILLER_59_860 VDD VSS sg13g2_decap_8
XFILLER_19_746 VDD VSS sg13g2_decap_8
XFILLER_18_245 VDD VSS sg13g2_decap_8
XFILLER_92_159 VDD VSS sg13g2_decap_8
XFILLER_41_270 VDD VSS sg13g2_decap_4
X_3560_ _3559_/Y VDD _4716_/D VSS _3563_/B _3608_/A sg13g2_o21ai_1
X_2511_ _4571_/Q _4572_/Q _3174_/A _3169_/B _3176_/B VDD VSS sg13g2_or4_1
XFILLER_115_537 VDD VSS sg13g2_decap_8
X_3491_ _3395_/B VDD _3491_/Y VSS _3393_/C _3390_/C sg13g2_o21ai_1
XFILLER_5_193 VDD VSS sg13g2_decap_8
X_2442_ _2809_/A _2442_/B _2442_/X VDD VSS sg13g2_and2_1
X_2373_ _2387_/B _4676_/Q _4668_/Q _2274_/Y _2273_/Y VDD VSS sg13g2_a22oi_1
XFILLER_110_220 VDD VSS sg13g2_decap_8
XFILLER_110_231 VDD VSS sg13g2_fill_1
XFILLER_68_123 VDD VSS sg13g2_fill_1
X_4455__471 VDD VSS _4455_/RESET_B sg13g2_tiehi
X_4112_ _4199_/A1 VDD _4112_/Y VSS _4196_/A1 _4396_/Q sg13g2_o21ai_1
XFILLER_68_167 VDD VSS sg13g2_decap_8
XFILLER_84_638 VDD VSS sg13g2_decap_8
X_4043_ _4227_/B1 VDD _4043_/Y VSS _4227_/A1 _4042_/X sg13g2_o21ai_1
XFILLER_96_487 VDD VSS sg13g2_decap_8
XFILLER_110_297 VDD VSS sg13g2_decap_8
XFILLER_65_830 VDD VSS sg13g2_decap_8
XFILLER_37_576 VDD VSS sg13g2_decap_8
XFILLER_64_340 VDD VSS sg13g2_decap_4
XFILLER_24_204 VDD VSS sg13g2_fill_2
XFILLER_80_855 VDD VSS sg13g2_decap_8
X_4945_ fanout279/X VSS VDD _4945_/D _4945_/Q _4946_/CLK sg13g2_dfrbpq_1
XFILLER_91_192 VDD VSS sg13g2_decap_8
XFILLER_33_793 VDD VSS sg13g2_decap_4
X_4876_ fanout304/X VSS VDD _4876_/D _4876_/Q _4877_/CLK sg13g2_dfrbpq_1
X_3827_ _3827_/Y _3827_/A _3827_/B VDD VSS sg13g2_nand2_1
X_3758_ _3758_/Y _3832_/A _3758_/B VDD VSS sg13g2_nand2_1
X_2709_ _3570_/A VDD _2711_/A VSS _2256_/Y _2708_/B sg13g2_o21ai_1
X_3689_ _3688_/Y _3681_/Y _3719_/A _3689_/X VDD VSS sg13g2_a21o_1
XFILLER_106_559 VDD VSS sg13g2_decap_8
XFILLER_0_837 VDD VSS sg13g2_decap_8
XFILLER_102_721 VDD VSS sg13g2_decap_8
XFILLER_59_101 VDD VSS sg13g2_decap_8
XFILLER_88_922 VDD VSS sg13g2_decap_4
XFILLER_48_808 VDD VSS sg13g2_decap_8
XFILLER_99_292 VDD VSS sg13g2_fill_2
XFILLER_114_43 VDD VSS sg13g2_decap_8
XFILLER_47_307 VDD VSS sg13g2_decap_8
XFILLER_56_830 VDD VSS sg13g2_decap_8
XFILLER_74_137 VDD VSS sg13g2_decap_8
XFILLER_74_14 VDD VSS sg13g2_fill_2
XFILLER_16_705 VDD VSS sg13g2_decap_4
XFILLER_55_351 VDD VSS sg13g2_decap_8
XFILLER_71_800 VDD VSS sg13g2_decap_4
XFILLER_74_47 VDD VSS sg13g2_fill_1
XFILLER_90_619 VDD VSS sg13g2_decap_8
XFILLER_15_215 VDD VSS sg13g2_decap_4
XFILLER_16_749 VDD VSS sg13g2_decap_8
XFILLER_71_844 VDD VSS sg13g2_decap_8
XFILLER_70_332 VDD VSS sg13g2_decap_8
XFILLER_11_410 VDD VSS sg13g2_decap_8
XFILLER_23_281 VDD VSS sg13g2_decap_8
XFILLER_24_793 VDD VSS sg13g2_decap_8
XFILLER_30_229 VDD VSS sg13g2_decap_8
XFILLER_8_904 VDD VSS sg13g2_decap_8
XFILLER_109_331 VDD VSS sg13g2_decap_8
XFILLER_7_458 VDD VSS sg13g2_decap_8
XFILLER_99_11 VDD VSS sg13g2_fill_2
XFILLER_3_620 VDD VSS sg13g2_fill_1
XFILLER_2_130 VDD VSS sg13g2_decap_4
XFILLER_105_581 VDD VSS sg13g2_decap_4
XFILLER_2_185 VDD VSS sg13g2_fill_1
XFILLER_78_454 VDD VSS sg13g2_decap_8
XFILLER_17_7 VDD VSS sg13g2_fill_1
XFILLER_66_638 VDD VSS sg13g2_decap_8
XFILLER_93_446 VDD VSS sg13g2_fill_1
XFILLER_62_800 VDD VSS sg13g2_decap_8
XFILLER_74_660 VDD VSS sg13g2_decap_8
XFILLER_0_77 VDD VSS sg13g2_decap_8
XFILLER_34_524 VDD VSS sg13g2_fill_1
XFILLER_62_844 VDD VSS sg13g2_decap_8
XFILLER_46_395 VDD VSS sg13g2_decap_8
XFILLER_61_343 VDD VSS sg13g2_decap_8
XFILLER_73_181 VDD VSS sg13g2_fill_1
X_2991_ hold866/X _3017_/A1 _3003_/S _4418_/D VDD VSS sg13g2_mux2_1
XFILLER_14_292 VDD VSS sg13g2_decap_8
XFILLER_15_793 VDD VSS sg13g2_fill_1
XFILLER_30_730 VDD VSS sg13g2_decap_8
X_4730_ fanout286/X VSS VDD _4730_/D _4730_/Q _4737_/CLK sg13g2_dfrbpq_1
X_4661_ fanout253/X VSS VDD _4661_/D _4661_/Q _4673_/CLK sg13g2_dfrbpq_1
X_3612_ _3612_/Y _3612_/A _3612_/B VDD VSS sg13g2_xnor2_1
XFILLER_116_824 VDD VSS sg13g2_decap_8
Xhold904 _4537_/Q VDD VSS hold904/X sg13g2_dlygate4sd3_1
X_4592_ fanout289/X VSS VDD _4592_/D _4592_/Q _4601_/CLK sg13g2_dfrbpq_1
Xhold926 _3013_/X VDD VSS _4439_/D sg13g2_dlygate4sd3_1
Xhold937 _2944_/X VDD VSS _4374_/D sg13g2_dlygate4sd3_1
Xhold915 _4269_/Q VDD VSS hold915/X sg13g2_dlygate4sd3_1
X_3543_ _3543_/A0 _3543_/A1 _3552_/S _4705_/D VDD VSS sg13g2_mux2_1
XFILLER_43_0 VDD VSS sg13g2_decap_8
Xhold948 _4546_/Q VDD VSS hold948/X sg13g2_dlygate4sd3_1
Xhold959 _3934_/Y VDD VSS _4817_/D sg13g2_dlygate4sd3_1
X_3474_ _3473_/Y VDD _3474_/Y VSS _2291_/Y _3473_/C sg13g2_o21ai_1
XFILLER_88_207 VDD VSS sg13g2_decap_8
XFILLER_115_378 VDD VSS sg13g2_decap_8
X_2425_ _2425_/Y _2425_/A _2809_/B VDD VSS sg13g2_nand2_1
XFILLER_69_432 VDD VSS sg13g2_decap_8
XFILLER_111_551 VDD VSS sg13g2_decap_4
XFILLER_111_562 VDD VSS sg13g2_decap_4
XFILLER_57_627 VDD VSS sg13g2_decap_8
XFILLER_84_413 VDD VSS sg13g2_fill_2
Xhold1604 _3753_/X VDD VSS _3754_/B1 sg13g2_dlygate4sd3_1
Xhold1615 _4769_/Q VDD VSS _3841_/A sg13g2_dlygate4sd3_1
Xhold1626 _3599_/Y VDD VSS _3600_/B sg13g2_dlygate4sd3_1
X_2356_ VDD _2356_/Y _3556_/A VSS sg13g2_inv_1
XFILLER_96_273 VDD VSS sg13g2_fill_1
XFILLER_96_262 VDD VSS sg13g2_decap_8
XFILLER_56_126 VDD VSS sg13g2_decap_8
XFILLER_84_424 VDD VSS sg13g2_decap_8
Xhold1637 _4782_/Q VDD VSS _2317_/A sg13g2_dlygate4sd3_1
Xhold1648 _4577_/Q VDD VSS _3183_/B1 sg13g2_dlygate4sd3_1
Xhold1659 _4790_/Q VDD VSS _2321_/A sg13g2_dlygate4sd3_1
X_2287_ VDD _2287_/Y _4680_/Q VSS sg13g2_inv_1
XFILLER_38_863 VDD VSS sg13g2_decap_8
XFILLER_38_874 VDD VSS sg13g2_fill_1
XFILLER_72_608 VDD VSS sg13g2_decap_8
X_4026_ _4026_/Y _4026_/B _4078_/A VDD VSS sg13g2_nand2b_1
XFILLER_65_682 VDD VSS sg13g2_fill_2
X_4386__340 VDD VSS _4386_/RESET_B sg13g2_tiehi
XFILLER_80_696 VDD VSS sg13g2_fill_1
XFILLER_21_741 VDD VSS sg13g2_fill_2
X_4928_ fanout316/X VSS VDD _4928_/D _4928_/Q _4929_/CLK sg13g2_dfrbpq_1
XFILLER_100_67 VDD VSS sg13g2_decap_4
XFILLER_100_89 VDD VSS sg13g2_decap_8
X_4347__379 VDD VSS _4347_/RESET_B sg13g2_tiehi
XFILLER_60_49 VDD VSS sg13g2_fill_2
X_4859_ fanout332/X VSS VDD _4859_/D _4859_/Q _4933_/CLK sg13g2_dfrbpq_1
XFILLER_109_21 VDD VSS sg13g2_decap_8
XFILLER_5_907 VDD VSS sg13g2_decap_8
XFILLER_107_846 VDD VSS sg13g2_decap_8
XFILLER_4_439 VDD VSS sg13g2_fill_1
XFILLER_0_634 VDD VSS sg13g2_decap_8
XFILLER_115_890 VDD VSS sg13g2_fill_2
XFILLER_47_104 VDD VSS sg13g2_decap_4
XFILLER_88_774 VDD VSS sg13g2_decap_4
XFILLER_87_284 VDD VSS sg13g2_decap_8
XFILLER_28_351 VDD VSS sg13g2_decap_8
XFILLER_63_608 VDD VSS sg13g2_decap_8
XFILLER_16_524 VDD VSS sg13g2_decap_8
XFILLER_18_84 VDD VSS sg13g2_decap_8
XFILLER_18_95 VDD VSS sg13g2_decap_4
XFILLER_44_811 VDD VSS sg13g2_decap_8
XFILLER_55_170 VDD VSS sg13g2_fill_1
XFILLER_56_671 VDD VSS sg13g2_decap_8
XFILLER_90_438 VDD VSS sg13g2_decap_8
XFILLER_55_192 VDD VSS sg13g2_decap_8
XFILLER_90_449 VDD VSS sg13g2_fill_2
XFILLER_71_685 VDD VSS sg13g2_decap_4
XFILLER_12_730 VDD VSS sg13g2_decap_8
XFILLER_70_184 VDD VSS sg13g2_decap_8
X_4445__481 VDD VSS _4445_/RESET_B sg13g2_tiehi
XFILLER_7_244 VDD VSS sg13g2_fill_2
XFILLER_8_789 VDD VSS sg13g2_fill_1
XFILLER_8_778 VDD VSS sg13g2_decap_8
XFILLER_50_82 VDD VSS sg13g2_decap_8
XFILLER_7_277 VDD VSS sg13g2_decap_8
XFILLER_112_315 VDD VSS sg13g2_decap_8
X_3190_ VSS VDD _3190_/A1 _3189_/Y _3190_/Y _3185_/A sg13g2_a21oi_1
X_4452__474 VDD VSS _4452_/RESET_B sg13g2_tiehi
XFILLER_94_744 VDD VSS sg13g2_decap_8
XFILLER_93_210 VDD VSS sg13g2_fill_2
XFILLER_19_340 VDD VSS sg13g2_decap_8
XFILLER_82_906 VDD VSS sg13g2_decap_8
XFILLER_19_384 VDD VSS sg13g2_decap_8
XFILLER_81_438 VDD VSS sg13g2_decap_4
XFILLER_81_449 VDD VSS sg13g2_decap_8
XFILLER_34_354 VDD VSS sg13g2_decap_4
XFILLER_61_151 VDD VSS sg13g2_decap_8
XFILLER_62_685 VDD VSS sg13g2_decap_8
XFILLER_22_538 VDD VSS sg13g2_decap_8
XFILLER_50_836 VDD VSS sg13g2_decap_8
X_2974_ _2974_/A0 _3103_/A0 _2975_/S _2974_/X VDD VSS sg13g2_mux2_1
X_4713_ fanout325/X VSS VDD _4713_/D _4713_/Q _4868_/CLK sg13g2_dfrbpq_1
X_4644_ fanout272/X VSS VDD _4644_/D _4644_/Q _4749_/CLK sg13g2_dfrbpq_1
XFILLER_116_610 VDD VSS sg13g2_decap_8
Xhold712 _3913_/Y VDD VSS hold712/X sg13g2_dlygate4sd3_1
Xhold701 _2581_/Y VDD VSS _4892_/D sg13g2_dlygate4sd3_1
X_4575_ fanout330/X VSS VDD _4575_/D _4575_/Q _4580_/CLK sg13g2_dfrbpq_1
Xhold745 _3274_/Y VDD VSS _4615_/D sg13g2_dlygate4sd3_1
Xhold734 _4830_/Q VDD VSS _2634_/A sg13g2_dlygate4sd3_1
Xhold723 _3940_/Y VDD VSS _4818_/D sg13g2_dlygate4sd3_1
X_3526_ _3525_/Y VDD _3527_/B VSS _2469_/A _3529_/B sg13g2_o21ai_1
XFILLER_115_164 VDD VSS sg13g2_decap_8
XFILLER_116_698 VDD VSS sg13g2_decap_8
Xhold778 _4601_/Q VDD VSS _2603_/C sg13g2_dlygate4sd3_1
Xhold767 _4804_/Q VDD VSS _2476_/A sg13g2_dlygate4sd3_1
Xhold756 _4965_/Q VDD VSS _2353_/A sg13g2_dlygate4sd3_1
XFILLER_103_326 VDD VSS sg13g2_decap_8
XFILLER_103_359 VDD VSS sg13g2_decap_8
XFILLER_115_197 VDD VSS sg13g2_decap_8
Xhold789 _2820_/X VDD VSS _4259_/D sg13g2_dlygate4sd3_1
X_3457_ _3473_/B _3475_/C _3457_/A _3457_/Y VDD VSS sg13g2_nand3_1
XFILLER_58_925 VDD VSS sg13g2_fill_1
Xhold1401 _4671_/Q VDD VSS _3465_/A sg13g2_dlygate4sd3_1
X_3388_ _3419_/C _4790_/Q _3388_/C _3388_/Y VDD VSS sg13g2_nor3_1
X_2408_ _2434_/A _2428_/B _2408_/C _2411_/D VDD VSS sg13g2_or3_1
XFILLER_97_560 VDD VSS sg13g2_fill_2
XFILLER_112_893 VDD VSS sg13g2_fill_1
XFILLER_29_126 VDD VSS sg13g2_decap_4
XFILLER_69_273 VDD VSS sg13g2_decap_8
Xhold1412 _4915_/Q VDD VSS _2437_/B sg13g2_dlygate4sd3_1
Xhold1423 _4870_/Q VDD VSS _3615_/A sg13g2_dlygate4sd3_1
Xhold1434 _3215_/Y VDD VSS _3216_/A2 sg13g2_dlygate4sd3_1
X_2339_ VDD _4866_/D _2787_/A VSS sg13g2_inv_1
XFILLER_29_148 VDD VSS sg13g2_decap_8
Xhold1445 _3654_/X VDD VSS _4749_/D sg13g2_dlygate4sd3_1
Xhold1456 _3908_/X VDD VSS _4811_/D sg13g2_dlygate4sd3_1
Xhold1467 _4954_/Q VDD VSS _2754_/A1 sg13g2_dlygate4sd3_1
XFILLER_26_822 VDD VSS sg13g2_fill_1
XFILLER_38_660 VDD VSS sg13g2_fill_2
XFILLER_38_671 VDD VSS sg13g2_fill_1
Xhold1478 _4771_/Q VDD VSS _3847_/A sg13g2_dlygate4sd3_1
Xhold1489 _3647_/Y VDD VSS _4743_/D sg13g2_dlygate4sd3_1
X_4009_ VSS VDD _2234_/Y _4005_/Y _4009_/Y _4008_/Y sg13g2_a21oi_1
XFILLER_85_799 VDD VSS sg13g2_decap_8
XFILLER_25_332 VDD VSS sg13g2_fill_2
XFILLER_13_505 VDD VSS sg13g2_decap_8
XFILLER_13_516 VDD VSS sg13g2_fill_1
XFILLER_25_354 VDD VSS sg13g2_decap_8
XFILLER_25_365 VDD VSS sg13g2_fill_1
XFILLER_52_151 VDD VSS sg13g2_decap_8
XFILLER_111_99 VDD VSS sg13g2_decap_8
XFILLER_5_704 VDD VSS sg13g2_decap_8
XFILLER_4_247 VDD VSS sg13g2_decap_8
XFILLER_106_175 VDD VSS sg13g2_decap_8
XFILLER_0_431 VDD VSS sg13g2_decap_8
XFILLER_96_34 VDD VSS sg13g2_fill_1
XFILLER_76_700 VDD VSS sg13g2_fill_1
XFILLER_102_370 VDD VSS sg13g2_decap_8
XFILLER_48_413 VDD VSS sg13g2_fill_1
XFILLER_76_766 VDD VSS sg13g2_decap_8
XFILLER_35_107 VDD VSS sg13g2_decap_8
XFILLER_63_416 VDD VSS sg13g2_decap_8
XFILLER_91_736 VDD VSS sg13g2_decap_8
XFILLER_90_213 VDD VSS sg13g2_fill_1
Xclkbuf_leaf_55_clk clkbuf_4_9_0_clk/X _4958_/CLK VDD VSS sg13g2_buf_8
XFILLER_44_652 VDD VSS sg13g2_decap_8
XFILLER_45_60 VDD VSS sg13g2_decap_8
XFILLER_71_493 VDD VSS sg13g2_decap_8
XFILLER_31_346 VDD VSS sg13g2_fill_1
XFILLER_61_70 VDD VSS sg13g2_decap_8
XFILLER_84_7 VDD VSS sg13g2_decap_8
X_2690_ VDD _2691_/C _2708_/B VSS sg13g2_inv_1
XFILLER_6_43 VDD VSS sg13g2_decap_8
X_4360_ _4360_/RESET_B VSS VDD _4360_/D _4360_/Q _4961_/CLK sg13g2_dfrbpq_1
X_3311_ _3413_/C _4785_/Q _3319_/B VDD VSS sg13g2_and2_1
XFILLER_99_825 VDD VSS sg13g2_decap_8
XFILLER_112_112 VDD VSS sg13g2_fill_2
XFILLER_4_781 VDD VSS sg13g2_decap_8
X_4376__350 VDD VSS _4376_/RESET_B sg13g2_tiehi
X_4291_ _4291_/RESET_B VSS VDD _4291_/D _4291_/Q clkload5/A sg13g2_dfrbpq_1
XFILLER_99_869 VDD VSS sg13g2_decap_8
XFILLER_98_324 VDD VSS sg13g2_decap_8
XFILLER_112_167 VDD VSS sg13g2_decap_8
X_3242_ _3281_/A _3278_/A _3242_/B VDD VSS sg13g2_nand2_1
X_3173_ _3182_/A _3173_/B _4572_/D VDD VSS sg13g2_nor2_1
XFILLER_39_457 VDD VSS sg13g2_decap_8
XFILLER_55_917 VDD VSS sg13g2_decap_8
XFILLER_66_232 VDD VSS sg13g2_decap_8
X_4337__389 VDD VSS _4337_/RESET_B sg13g2_tiehi
XFILLER_94_552 VDD VSS sg13g2_decap_4
XFILLER_67_788 VDD VSS sg13g2_fill_1
Xclkbuf_leaf_46_clk clkbuf_4_10_0_clk/X _4974_/CLK VDD VSS sg13g2_buf_8
XFILLER_34_140 VDD VSS sg13g2_decap_8
XFILLER_23_847 VDD VSS sg13g2_decap_8
XFILLER_35_685 VDD VSS sg13g2_decap_8
XFILLER_62_493 VDD VSS sg13g2_decap_8
XFILLER_22_335 VDD VSS sg13g2_decap_8
XFILLER_50_666 VDD VSS sg13g2_decap_8
X_4383__343 VDD VSS _4383_/RESET_B sg13g2_tiehi
X_2957_ hold895/X _3086_/A0 _2981_/S _4386_/D VDD VSS sg13g2_mux2_1
X_2888_ hold826/X _3096_/A0 _2896_/S _2888_/X VDD VSS sg13g2_mux2_1
X_4627_ fanout264/X VSS VDD _4627_/D _4627_/Q _4658_/CLK sg13g2_dfrbpq_1
XFILLER_104_613 VDD VSS sg13g2_decap_8
XFILLER_2_729 VDD VSS sg13g2_decap_8
Xhold542 _4862_/Q VDD VSS _4932_/D sg13g2_dlygate4sd3_1
Xhold553 _4689_/Q VDD VSS _3519_/A sg13g2_dlygate4sd3_1
X_4558_ fanout299/X VSS VDD _4558_/D _4558_/Q _4967_/CLK sg13g2_dfrbpq_1
XFILLER_103_101 VDD VSS sg13g2_decap_4
XFILLER_103_112 VDD VSS sg13g2_decap_8
XFILLER_116_484 VDD VSS sg13g2_decap_8
Xhold564 _4691_/Q VDD VSS hold564/X sg13g2_dlygate4sd3_1
Xhold575 _3137_/Y VDD VSS _4556_/D sg13g2_dlygate4sd3_1
Xhold586 _2570_/Y VDD VSS _2573_/A sg13g2_dlygate4sd3_1
Xhold597 _4690_/Q VDD VSS _2469_/A sg13g2_dlygate4sd3_1
X_4489_ fanout321/X VSS VDD _4489_/D _4489_/Q _4979_/CLK sg13g2_dfrbpq_1
X_3509_ _3509_/A _3508_/Y _4685_/D VDD VSS sg13g2_nor2b_1
XFILLER_104_668 VDD VSS sg13g2_decap_8
XFILLER_58_722 VDD VSS sg13g2_decap_8
XFILLER_57_221 VDD VSS sg13g2_decap_8
Xhold1220 _4454_/Q VDD VSS _3028_/A0 sg13g2_dlygate4sd3_1
Xhold1231 _4263_/Q VDD VSS _2826_/A0 sg13g2_dlygate4sd3_1
Xhold1242 _4909_/Q VDD VSS _2800_/A sg13g2_dlygate4sd3_1
X_4435__491 VDD VSS _4435_/RESET_B sg13g2_tiehi
Xhold1253 _4959_/Q VDD VSS _4057_/B sg13g2_dlygate4sd3_1
Xhold1264 _3535_/X VDD VSS _4697_/D sg13g2_dlygate4sd3_1
Xhold1275 _4309_/Q VDD VSS _2874_/A0 sg13g2_dlygate4sd3_1
XFILLER_72_235 VDD VSS sg13g2_fill_1
Xhold1286 _3512_/Y VDD VSS _4686_/D sg13g2_dlygate4sd3_1
Xhold1297 _4676_/Q VDD VSS _3475_/A sg13g2_dlygate4sd3_1
Xclkbuf_leaf_37_clk clkbuf_4_12_0_clk/X _4972_/CLK VDD VSS sg13g2_buf_8
XFILLER_25_151 VDD VSS sg13g2_fill_1
XFILLER_72_268 VDD VSS sg13g2_decap_8
XFILLER_82_47 VDD VSS sg13g2_decap_8
XFILLER_40_132 VDD VSS sg13g2_fill_1
XFILLER_40_176 VDD VSS sg13g2_fill_1
X_4442__484 VDD VSS _4442_/RESET_B sg13g2_tiehi
XFILLER_110_0 VDD VSS sg13g2_decap_8
XFILLER_31_84 VDD VSS sg13g2_decap_8
XFILLER_5_578 VDD VSS sg13g2_fill_1
XFILLER_110_605 VDD VSS sg13g2_fill_2
XFILLER_1_740 VDD VSS sg13g2_decap_8
XFILLER_89_880 VDD VSS sg13g2_fill_2
XFILLER_103_690 VDD VSS sg13g2_decap_8
XFILLER_49_777 VDD VSS sg13g2_decap_8
XFILLER_88_390 VDD VSS sg13g2_fill_1
XFILLER_36_405 VDD VSS sg13g2_decap_8
XFILLER_48_265 VDD VSS sg13g2_decap_8
XFILLER_64_714 VDD VSS sg13g2_decap_8
XFILLER_76_574 VDD VSS sg13g2_decap_4
XFILLER_56_70 VDD VSS sg13g2_decap_8
Xclkbuf_leaf_28_clk clkbuf_4_13_0_clk/X _4931_/CLK VDD VSS sg13g2_buf_8
XFILLER_16_151 VDD VSS sg13g2_fill_2
XFILLER_72_780 VDD VSS sg13g2_decap_8
XFILLER_16_195 VDD VSS sg13g2_decap_4
X_3860_ _3863_/S _3868_/A _3868_/B VDD VSS sg13g2_nand2b_1
X_3791_ _3790_/Y _3489_/A _3791_/S _4775_/D VDD VSS sg13g2_mux2_1
X_2811_ _2813_/A _2811_/B _4920_/D VDD VSS sg13g2_nor2_1
XFILLER_31_198 VDD VSS sg13g2_decap_8
X_2742_ _2742_/A _2742_/B _2748_/C VDD VSS sg13g2_nor2_1
XFILLER_9_884 VDD VSS sg13g2_decap_8
XFILLER_8_350 VDD VSS sg13g2_decap_8
X_4412_ _4412_/RESET_B VSS VDD _4412_/D _4412_/Q clkload8/A sg13g2_dfrbpq_1
X_2673_ _2655_/A VDD _2673_/Y VSS _2664_/Y _2672_/Y sg13g2_o21ai_1
XFILLER_99_600 VDD VSS sg13g2_decap_8
XFILLER_113_432 VDD VSS sg13g2_decap_8
X_4343_ _4343_/RESET_B VSS VDD _4343_/D _4343_/Q _4968_/CLK sg13g2_dfrbpq_1
XFILLER_101_605 VDD VSS sg13g2_decap_8
Xfanout307 fanout311/X fanout307/X VDD VSS sg13g2_buf_1
Xfanout318 fanout319/X _2849_/C VDD VSS sg13g2_buf_1
Xfanout329 fanout331/X fanout329/X VDD VSS sg13g2_buf_1
X_4274_ _4274_/RESET_B VSS VDD _4274_/D _4274_/Q _4968_/CLK sg13g2_dfrbpq_1
XFILLER_101_638 VDD VSS sg13g2_decap_8
X_3225_ _3230_/A _3225_/B _4595_/D VDD VSS sg13g2_nor2_1
XFILLER_100_137 VDD VSS sg13g2_decap_8
X_3156_ _3156_/B _3156_/A _3156_/X VDD VSS sg13g2_xor2_1
XFILLER_36_29 VDD VSS sg13g2_fill_2
XFILLER_82_544 VDD VSS sg13g2_decap_4
Xclkbuf_leaf_19_clk clkbuf_4_7_0_clk/X _4817_/CLK VDD VSS sg13g2_buf_8
X_3087_ _3087_/A0 hold841/X _3109_/S _4511_/D VDD VSS sg13g2_mux2_1
XFILLER_54_246 VDD VSS sg13g2_decap_8
XFILLER_23_633 VDD VSS sg13g2_fill_1
XFILLER_52_28 VDD VSS sg13g2_decap_8
X_3989_ _3989_/Y _3989_/A _4003_/B VDD VSS sg13g2_nand2_1
XFILLER_109_749 VDD VSS sg13g2_decap_8
XFILLER_108_237 VDD VSS sg13g2_decap_8
XFILLER_104_421 VDD VSS sg13g2_decap_8
XFILLER_116_270 VDD VSS sg13g2_decap_8
XFILLER_77_14 VDD VSS sg13g2_decap_4
XFILLER_77_316 VDD VSS sg13g2_fill_1
XFILLER_77_338 VDD VSS sg13g2_decap_8
Xclkbuf_4_13_0_clk clkbuf_0_clk/X clkbuf_4_13_0_clk/X VDD VSS sg13g2_buf_8
XFILLER_18_405 VDD VSS sg13g2_decap_8
Xhold1050 _4552_/Q VDD VSS _3128_/A sg13g2_dlygate4sd3_1
XFILLER_86_883 VDD VSS sg13g2_decap_4
Xhold1061 _4499_/Q VDD VSS _3075_/A1 sg13g2_dlygate4sd3_1
Xhold1072 _2894_/X VDD VSS _4327_/D sg13g2_dlygate4sd3_1
Xhold1083 _4319_/Q VDD VSS _2886_/A0 sg13g2_dlygate4sd3_1
Xhold1094 _4266_/Q VDD VSS _2829_/A0 sg13g2_dlygate4sd3_1
XFILLER_45_246 VDD VSS sg13g2_decap_8
XFILLER_45_257 VDD VSS sg13g2_fill_1
XFILLER_26_471 VDD VSS sg13g2_decap_8
XFILLER_54_791 VDD VSS sg13g2_decap_8
XFILLER_14_633 VDD VSS sg13g2_decap_8
XFILLER_26_95 VDD VSS sg13g2_decap_8
XFILLER_13_154 VDD VSS sg13g2_decap_8
XFILLER_13_176 VDD VSS sg13g2_decap_8
X_4366__360 VDD VSS _4366_/RESET_B sg13g2_tiehi
XFILLER_9_103 VDD VSS sg13g2_decap_8
XFILLER_42_72 VDD VSS sg13g2_decap_8
X_4327__399 VDD VSS _4327_/RESET_B sg13g2_tiehi
XFILLER_6_854 VDD VSS sg13g2_decap_8
XFILLER_5_342 VDD VSS sg13g2_decap_8
XFILLER_47_7 VDD VSS sg13g2_decap_8
XFILLER_111_925 VDD VSS sg13g2_fill_1
X_4373__353 VDD VSS _4373_/RESET_B sg13g2_tiehi
XFILLER_110_468 VDD VSS sg13g2_decap_8
XFILLER_49_563 VDD VSS sg13g2_decap_8
XFILLER_64_500 VDD VSS sg13g2_fill_1
XFILLER_67_91 VDD VSS sg13g2_decap_8
X_3010_ hold981/X hold798/X _3034_/S _4436_/D VDD VSS sg13g2_mux2_1
XFILLER_91_330 VDD VSS sg13g2_fill_1
XFILLER_64_555 VDD VSS sg13g2_decap_8
XFILLER_92_875 VDD VSS sg13g2_fill_1
XFILLER_17_471 VDD VSS sg13g2_decap_8
XFILLER_17_482 VDD VSS sg13g2_fill_2
XFILLER_52_728 VDD VSS sg13g2_decap_8
X_4961_ fanout320/X VSS VDD _4961_/D _4961_/Q _4961_/CLK sg13g2_dfrbpq_1
XFILLER_91_396 VDD VSS sg13g2_fill_2
XFILLER_32_441 VDD VSS sg13g2_decap_8
X_4892_ fanout311/X VSS VDD _4892_/D _4892_/Q _4894_/CLK sg13g2_dfrbpq_1
X_3912_ _3915_/B _3939_/C _3912_/B VDD VSS sg13g2_nand2_1
XFILLER_60_783 VDD VSS sg13g2_decap_8
X_3843_ _3843_/Y _3852_/A _3842_/Y _3791_/S _3399_/A VDD VSS sg13g2_a22oi_1
XFILLER_20_669 VDD VSS sg13g2_decap_8
XFILLER_73_0 VDD VSS sg13g2_decap_8
X_4380__346 VDD VSS _4380_/RESET_B sg13g2_tiehi
X_3774_ _3774_/Y _3844_/A _3788_/B VDD VSS sg13g2_nand2_1
X_2725_ _2725_/A _2749_/A _2727_/B _4944_/D VDD VSS sg13g2_nor3_1
XFILLER_9_692 VDD VSS sg13g2_fill_1
XFILLER_8_180 VDD VSS sg13g2_decap_4
Xclkbuf_leaf_8_clk clkbuf_4_6_0_clk/X _4737_/CLK VDD VSS sg13g2_buf_8
X_2656_ _3519_/A _2656_/B _2698_/B VDD VSS sg13g2_nor2_1
XFILLER_102_914 VDD VSS sg13g2_decap_8
Xfanout104 fanout108/X _2873_/S VDD VSS sg13g2_buf_1
X_2587_ _4599_/Q _2603_/B _2602_/A VDD VSS sg13g2_nor2_1
XFILLER_101_413 VDD VSS sg13g2_decap_8
XFILLER_102_925 VDD VSS sg13g2_fill_1
Xfanout115 _2756_/Y _3758_/B VDD VSS sg13g2_buf_1
Xfanout126 _2585_/Y _3184_/B VDD VSS sg13g2_buf_1
Xfanout137 _4241_/A1 _4205_/A1 VDD VSS sg13g2_buf_1
X_4326_ _4326_/RESET_B VSS VDD _4326_/D _4326_/Q _4961_/CLK sg13g2_dfrbpq_1
XFILLER_86_102 VDD VSS sg13g2_decap_8
Xfanout148 _3110_/S _3109_/S VDD VSS sg13g2_buf_1
Xfanout159 _4245_/B1 _4218_/B1 VDD VSS sg13g2_buf_1
X_4257_ _4257_/A _4901_/D VDD VSS sg13g2_buf_1
X_4188_ _4188_/B1 VDD _4188_/Y VSS _4188_/A1 _4403_/Q sg13g2_o21ai_1
X_3208_ _3208_/B _3208_/A _3208_/X VDD VSS sg13g2_xor2_1
XFILLER_28_747 VDD VSS sg13g2_decap_8
XFILLER_55_511 VDD VSS sg13g2_decap_8
XFILLER_67_382 VDD VSS sg13g2_decap_8
XFILLER_83_820 VDD VSS sg13g2_decap_4
X_3139_ _3138_/Y VDD _3139_/Y VSS _4630_/Q _3138_/B sg13g2_o21ai_1
XFILLER_103_45 VDD VSS sg13g2_decap_8
XFILLER_15_408 VDD VSS sg13g2_decap_8
X_4432__494 VDD VSS _4432_/RESET_B sg13g2_tiehi
XFILLER_43_728 VDD VSS sg13g2_decap_8
XFILLER_63_49 VDD VSS sg13g2_decap_8
XFILLER_11_636 VDD VSS sg13g2_fill_1
XFILLER_11_658 VDD VSS sg13g2_decap_8
XFILLER_10_157 VDD VSS sg13g2_decap_8
XFILLER_6_106 VDD VSS sg13g2_decap_8
XFILLER_12_42 VDD VSS sg13g2_decap_8
XFILLER_2_323 VDD VSS sg13g2_decap_8
XFILLER_3_835 VDD VSS sg13g2_decap_8
XFILLER_88_46 VDD VSS sg13g2_fill_1
XFILLER_2_334 VDD VSS sg13g2_fill_1
XFILLER_78_603 VDD VSS sg13g2_decap_8
XFILLER_105_785 VDD VSS sg13g2_decap_4
XFILLER_19_725 VDD VSS sg13g2_decap_8
XFILLER_92_138 VDD VSS sg13g2_decap_8
XFILLER_74_864 VDD VSS sg13g2_decap_8
XFILLER_33_205 VDD VSS sg13g2_decap_8
XFILLER_73_374 VDD VSS sg13g2_decap_8
XFILLER_33_249 VDD VSS sg13g2_fill_2
XFILLER_14_463 VDD VSS sg13g2_decap_8
XFILLER_14_474 VDD VSS sg13g2_fill_1
XFILLER_42_761 VDD VSS sg13g2_decap_4
XFILLER_42_783 VDD VSS sg13g2_decap_8
XFILLER_14_496 VDD VSS sg13g2_decap_4
XFILLER_115_516 VDD VSS sg13g2_decap_8
XFILLER_6_662 VDD VSS sg13g2_decap_8
X_3490_ _3487_/A _3489_/X _3490_/S _4682_/D VDD VSS sg13g2_mux2_1
X_2510_ _3169_/A _2510_/B _3169_/B _3174_/B VDD VSS sg13g2_nor3_1
X_2441_ _4913_/Q VDD _2442_/B VSS _2433_/A _2805_/B sg13g2_o21ai_1
XFILLER_111_700 VDD VSS sg13g2_fill_1
XFILLER_68_102 VDD VSS sg13g2_decap_8
X_2372_ VSS VDD _4681_/Q _4673_/Q _2387_/A _2371_/Y sg13g2_a21oi_1
XFILLER_111_744 VDD VSS sg13g2_fill_1
XFILLER_2_890 VDD VSS sg13g2_decap_8
XFILLER_68_146 VDD VSS sg13g2_decap_8
X_4111_ _4118_/S _4371_/Q _4111_/Y VDD VSS sg13g2_nor2_1
XFILLER_96_444 VDD VSS sg13g2_fill_1
XFILLER_96_433 VDD VSS sg13g2_decap_8
XFILLER_56_308 VDD VSS sg13g2_decap_8
XFILLER_84_617 VDD VSS sg13g2_decap_8
X_4042_ _4038_/A _4264_/Q _4289_/Q _4314_/Q _4339_/Q _4172_/S1 _4042_/X VDD VSS sg13g2_mux4_1
XFILLER_110_276 VDD VSS sg13g2_decap_8
XFILLER_49_371 VDD VSS sg13g2_decap_8
XFILLER_77_680 VDD VSS sg13g2_decap_8
XFILLER_37_555 VDD VSS sg13g2_decap_8
XFILLER_83_149 VDD VSS sg13g2_decap_8
XFILLER_18_780 VDD VSS sg13g2_decap_8
XFILLER_65_897 VDD VSS sg13g2_decap_8
XFILLER_80_834 VDD VSS sg13g2_decap_8
XFILLER_91_171 VDD VSS sg13g2_decap_8
XFILLER_24_238 VDD VSS sg13g2_decap_4
X_4944_ fanout279/X VSS VDD _4944_/D _4944_/Q _4946_/CLK sg13g2_dfrbpq_1
XFILLER_33_783 VDD VSS sg13g2_fill_1
X_4875_ fanout304/X VSS VDD _4875_/D _4875_/Q _4877_/CLK sg13g2_dfrbpq_1
X_3826_ _3827_/B _3826_/A _3826_/B VDD VSS sg13g2_xnor2_1
XFILLER_20_477 VDD VSS sg13g2_decap_8
XFILLER_20_488 VDD VSS sg13g2_fill_1
X_3757_ _3757_/B1 VDD _3757_/Y VSS _3786_/B _3756_/Y sg13g2_o21ai_1
XFILLER_106_505 VDD VSS sg13g2_fill_2
X_2708_ _2708_/A _2708_/B _3595_/A VDD VSS sg13g2_and2_1
XFILLER_106_538 VDD VSS sg13g2_decap_8
X_3688_ _3688_/B _3688_/C _3688_/A _3688_/Y VDD VSS sg13g2_nand3_1
X_2639_ _2640_/A _2639_/B1 _2469_/A _2466_/A _3058_/S VDD VSS sg13g2_a22oi_1
XFILLER_0_816 VDD VSS sg13g2_decap_8
XFILLER_102_700 VDD VSS sg13g2_decap_8
X_4309_ _4309_/RESET_B VSS VDD _4309_/D _4309_/Q _4971_/CLK sg13g2_dfrbpq_1
XFILLER_87_444 VDD VSS sg13g2_decap_4
XFILLER_101_254 VDD VSS sg13g2_decap_8
XFILLER_102_777 VDD VSS sg13g2_fill_1
XFILLER_114_11 VDD VSS sg13g2_decap_8
XFILLER_59_179 VDD VSS sg13g2_decap_8
XFILLER_75_606 VDD VSS sg13g2_decap_8
XFILLER_75_617 VDD VSS sg13g2_fill_2
X_4356__370 VDD VSS _4356_/RESET_B sg13g2_tiehi
XFILLER_87_477 VDD VSS sg13g2_decap_8
XFILLER_55_330 VDD VSS sg13g2_decap_8
XFILLER_28_599 VDD VSS sg13g2_decap_8
XFILLER_56_886 VDD VSS sg13g2_decap_8
XFILLER_70_311 VDD VSS sg13g2_decap_8
XFILLER_43_547 VDD VSS sg13g2_decap_8
XFILLER_71_867 VDD VSS sg13g2_fill_1
XFILLER_12_923 VDD VSS sg13g2_fill_2
XFILLER_30_208 VDD VSS sg13g2_decap_8
XFILLER_70_388 VDD VSS sg13g2_decap_8
XFILLER_71_889 VDD VSS sg13g2_decap_8
XFILLER_90_36 VDD VSS sg13g2_fill_1
XFILLER_90_25 VDD VSS sg13g2_fill_2
XFILLER_90_14 VDD VSS sg13g2_decap_8
XFILLER_11_433 VDD VSS sg13g2_fill_1
X_4363__363 VDD VSS _4363_/RESET_B sg13g2_tiehi
XFILLER_109_310 VDD VSS sg13g2_decap_8
XFILLER_23_96 VDD VSS sg13g2_decap_8
XFILLER_109_387 VDD VSS sg13g2_decap_8
XFILLER_112_508 VDD VSS sg13g2_fill_1
XFILLER_3_0 VDD VSS sg13g2_decap_8
XFILLER_105_560 VDD VSS sg13g2_decap_8
XFILLER_78_411 VDD VSS sg13g2_fill_2
XFILLER_65_105 VDD VSS sg13g2_decap_8
XFILLER_66_617 VDD VSS sg13g2_decap_8
X_4370__356 VDD VSS _4370_/RESET_B sg13g2_tiehi
XFILLER_0_56 VDD VSS sg13g2_decap_8
XFILLER_19_577 VDD VSS sg13g2_decap_8
XFILLER_47_886 VDD VSS sg13g2_decap_8
XFILLER_80_119 VDD VSS sg13g2_decap_8
XFILLER_61_322 VDD VSS sg13g2_decap_8
XFILLER_64_70 VDD VSS sg13g2_decap_4
XFILLER_21_208 VDD VSS sg13g2_fill_1
X_2990_ hold882/X _3092_/A0 _3008_/S _4417_/D VDD VSS sg13g2_mux2_1
XFILLER_9_21 VDD VSS sg13g2_decap_8
XFILLER_14_260 VDD VSS sg13g2_fill_2
XFILLER_42_580 VDD VSS sg13g2_decap_8
XFILLER_61_399 VDD VSS sg13g2_decap_8
XFILLER_9_32 VDD VSS sg13g2_fill_1
X_4660_ fanout254/X VSS VDD _4660_/D _4660_/Q _4673_/CLK sg13g2_dfrbpq_1
XFILLER_80_91 VDD VSS sg13g2_decap_8
X_3611_ _3614_/B _3612_/A _3612_/B VDD VSS sg13g2_nand2_1
XFILLER_116_803 VDD VSS sg13g2_decap_8
X_4591_ fanout281/X VSS VDD _4591_/D _4591_/Q _4619_/CLK sg13g2_dfrbpq_1
XFILLER_115_324 VDD VSS sg13g2_decap_8
Xhold927 _4799_/Q VDD VSS hold927/X sg13g2_dlygate4sd3_1
Xhold916 _2832_/X VDD VSS _4269_/D sg13g2_dlygate4sd3_1
Xhold905 _3113_/X VDD VSS _4537_/D sg13g2_dlygate4sd3_1
X_3542_ _4704_/Q hold790/X _3550_/S _3542_/X VDD VSS sg13g2_mux2_1
XFILLER_115_335 VDD VSS sg13g2_fill_1
Xhold938 _4456_/Q VDD VSS hold938/X sg13g2_dlygate4sd3_1
Xhold949 _3097_/X VDD VSS _4521_/D sg13g2_dlygate4sd3_1
X_3473_ _3473_/B _3473_/C _3473_/A _3473_/Y VDD VSS sg13g2_nand3_1
XFILLER_69_411 VDD VSS sg13g2_decap_8
X_2424_ _2423_/Y VDD _2424_/Y VSS _2357_/A _2422_/Y sg13g2_o21ai_1
XFILLER_36_0 VDD VSS sg13g2_decap_8
X_2355_ VDD _3626_/A _3627_/A VSS sg13g2_inv_1
XFILLER_97_753 VDD VSS sg13g2_decap_8
XFILLER_57_606 VDD VSS sg13g2_decap_8
Xhold1605 _3754_/Y VDD VSS _4764_/D sg13g2_dlygate4sd3_1
Xhold1616 _4587_/Q VDD VSS _2302_/A sg13g2_dlygate4sd3_1
XFILLER_96_241 VDD VSS sg13g2_decap_8
XFILLER_56_105 VDD VSS sg13g2_decap_8
Xhold1627 _4589_/Q VDD VSS _2593_/B sg13g2_dlygate4sd3_1
Xhold1638 _3825_/Y VDD VSS _4782_/D sg13g2_dlygate4sd3_1
Xhold1649 _3184_/Y VDD VSS hold1649/X sg13g2_dlygate4sd3_1
X_2286_ VDD _2286_/Y _3465_/A VSS sg13g2_inv_1
XFILLER_37_330 VDD VSS sg13g2_decap_8
X_4025_ _4078_/A VDD _4025_/Y VSS _4218_/A1 _4024_/X sg13g2_o21ai_1
XFILLER_25_514 VDD VSS sg13g2_decap_8
XFILLER_65_661 VDD VSS sg13g2_decap_8
XFILLER_92_480 VDD VSS sg13g2_decap_8
XFILLER_12_208 VDD VSS sg13g2_decap_8
XFILLER_21_720 VDD VSS sg13g2_decap_8
XFILLER_33_580 VDD VSS sg13g2_fill_1
X_4927_ fanout291/X VSS VDD _4927_/D _4927_/Q _4927_/CLK sg13g2_dfrbpq_1
XFILLER_20_241 VDD VSS sg13g2_decap_8
XFILLER_60_28 VDD VSS sg13g2_decap_8
X_4858_ fanout274/X VSS VDD _4858_/D _4858_/Q _4942_/CLK sg13g2_dfrbpq_1
XFILLER_20_252 VDD VSS sg13g2_fill_1
X_3809_ _3809_/Y _3809_/A _3827_/A VDD VSS sg13g2_nand2_1
X_4789_ fanout248/X VSS VDD _4789_/D _4789_/Q clkload2/A sg13g2_dfrbpq_1
XFILLER_106_324 VDD VSS sg13g2_decap_4
XFILLER_107_825 VDD VSS sg13g2_decap_8
XFILLER_109_99 VDD VSS sg13g2_decap_8
XFILLER_0_613 VDD VSS sg13g2_decap_8
XFILLER_88_753 VDD VSS sg13g2_decap_8
XFILLER_85_14 VDD VSS sg13g2_decap_8
XFILLER_87_263 VDD VSS sg13g2_fill_1
XFILLER_87_252 VDD VSS sg13g2_decap_8
XFILLER_47_127 VDD VSS sg13g2_decap_4
XFILLER_75_414 VDD VSS sg13g2_decap_8
XFILLER_56_650 VDD VSS sg13g2_decap_4
XFILLER_91_918 VDD VSS sg13g2_decap_8
XFILLER_16_503 VDD VSS sg13g2_fill_2
XFILLER_18_63 VDD VSS sg13g2_decap_4
XFILLER_29_875 VDD VSS sg13g2_decap_8
XFILLER_56_661 VDD VSS sg13g2_fill_1
XFILLER_62_108 VDD VSS sg13g2_decap_8
XFILLER_90_417 VDD VSS sg13g2_decap_8
XFILLER_43_322 VDD VSS sg13g2_fill_2
XFILLER_44_867 VDD VSS sg13g2_decap_8
XFILLER_70_163 VDD VSS sg13g2_decap_8
XFILLER_71_664 VDD VSS sg13g2_decap_8
XFILLER_34_62 VDD VSS sg13g2_decap_8
XFILLER_12_742 VDD VSS sg13g2_decap_8
XFILLER_34_95 VDD VSS sg13g2_decap_8
XFILLER_12_775 VDD VSS sg13g2_decap_8
XFILLER_7_223 VDD VSS sg13g2_decap_8
XFILLER_11_296 VDD VSS sg13g2_decap_8
XFILLER_8_757 VDD VSS sg13g2_decap_8
XFILLER_98_539 VDD VSS sg13g2_decap_8
XFILLER_79_742 VDD VSS sg13g2_decap_8
XFILLER_94_723 VDD VSS sg13g2_decap_8
XFILLER_38_138 VDD VSS sg13g2_decap_8
XFILLER_66_469 VDD VSS sg13g2_decap_8
XFILLER_47_683 VDD VSS sg13g2_fill_1
XFILLER_75_91 VDD VSS sg13g2_decap_8
XFILLER_93_266 VDD VSS sg13g2_fill_2
XFILLER_34_333 VDD VSS sg13g2_decap_8
XFILLER_22_506 VDD VSS sg13g2_decap_8
XFILLER_50_815 VDD VSS sg13g2_decap_8
XFILLER_61_130 VDD VSS sg13g2_decap_8
X_2973_ _4175_/A1 _3026_/A1 _2980_/S _2973_/X VDD VSS sg13g2_mux2_1
X_4712_ fanout307/X VSS VDD _4712_/D _4712_/Q _4978_/CLK sg13g2_dfrbpq_1
X_4346__380 VDD VSS _4346_/RESET_B sg13g2_tiehi
X_4643_ fanout268/X VSS VDD _4643_/D _4643_/Q _4745_/CLK sg13g2_dfrbpq_1
Xhold702 _4752_/Q VDD VSS _2342_/A sg13g2_dlygate4sd3_1
X_4574_ fanout330/X VSS VDD _4574_/D _4574_/Q _4580_/CLK sg13g2_dfrbpq_1
XFILLER_115_110 VDD VSS sg13g2_decap_8
XFILLER_116_655 VDD VSS sg13g2_decap_8
XFILLER_7_790 VDD VSS sg13g2_decap_8
Xhold746 _4925_/Q VDD VSS _2358_/A sg13g2_dlygate4sd3_1
Xhold735 _2628_/Y VDD VSS _2635_/B sg13g2_dlygate4sd3_1
Xhold724 _4612_/Q VDD VSS _3265_/B sg13g2_dlygate4sd3_1
Xhold713 _4650_/Q VDD VSS _2402_/B sg13g2_dlygate4sd3_1
X_3525_ VSS VDD _2705_/A _3529_/B _3525_/Y _4932_/D sg13g2_a21oi_1
XFILLER_116_677 VDD VSS sg13g2_decap_8
Xhold779 _3239_/X VDD VSS _4601_/D sg13g2_dlygate4sd3_1
Xhold768 _3883_/Y VDD VSS hold768/X sg13g2_dlygate4sd3_1
Xhold757 _4122_/Y VDD VSS _4965_/D sg13g2_dlygate4sd3_1
X_3456_ _3455_/Y VDD _4665_/D VSS _2273_/Y _3475_/C sg13g2_o21ai_1
XFILLER_112_861 VDD VSS sg13g2_decap_8
XFILLER_112_872 VDD VSS sg13g2_fill_1
X_3387_ VSS VDD _3405_/C _3386_/Y _3388_/C _3405_/A sg13g2_a21oi_1
X_2407_ _2798_/A _2407_/C _2806_/A _2408_/C VDD VSS _2431_/C sg13g2_nand4_1
XFILLER_111_371 VDD VSS sg13g2_decap_8
XFILLER_29_105 VDD VSS sg13g2_decap_8
Xhold1402 _4656_/Q VDD VSS _3435_/A sg13g2_dlygate4sd3_1
Xhold1413 _2437_/Y VDD VSS _2438_/C sg13g2_dlygate4sd3_1
Xhold1424 _4723_/Q VDD VSS _3602_/A sg13g2_dlygate4sd3_1
X_2338_ VDD _3722_/A _3719_/A VSS sg13g2_inv_1
XFILLER_85_734 VDD VSS sg13g2_decap_8
Xhold1435 _4759_/Q VDD VSS _3735_/A sg13g2_dlygate4sd3_1
Xhold1446 _4736_/Q VDD VSS _3624_/A0 sg13g2_dlygate4sd3_1
Xhold1457 _4625_/Q VDD VSS _3618_/A1 sg13g2_dlygate4sd3_1
Xhold1468 _4748_/Q VDD VSS _3653_/A0 sg13g2_dlygate4sd3_1
X_4353__373 VDD VSS _4353_/RESET_B sg13g2_tiehi
X_2269_ VDD _2269_/Y _3449_/A VSS sg13g2_inv_1
XFILLER_55_28 VDD VSS sg13g2_decap_8
Xhold1479 _3781_/Y VDD VSS _4771_/D sg13g2_dlygate4sd3_1
X_4008_ VSS VDD _2629_/Y _4007_/Y _4008_/Y _4005_/Y sg13g2_a21oi_1
XFILLER_37_182 VDD VSS sg13g2_decap_8
XFILLER_72_439 VDD VSS sg13g2_decap_8
XFILLER_111_56 VDD VSS sg13g2_decap_8
XFILLER_26_867 VDD VSS sg13g2_decap_8
XFILLER_41_815 VDD VSS sg13g2_fill_1
XFILLER_52_130 VDD VSS sg13g2_decap_8
XFILLER_111_78 VDD VSS sg13g2_decap_8
XFILLER_41_859 VDD VSS sg13g2_decap_8
XFILLER_80_472 VDD VSS sg13g2_decap_4
XFILLER_40_369 VDD VSS sg13g2_decap_8
XFILLER_4_204 VDD VSS sg13g2_decap_8
X_4360__366 VDD VSS _4360_/RESET_B sg13g2_tiehi
XFILLER_106_121 VDD VSS sg13g2_decap_8
XFILLER_20_42 VDD VSS sg13g2_decap_8
XFILLER_4_226 VDD VSS sg13g2_decap_8
XFILLER_107_699 VDD VSS sg13g2_decap_8
XFILLER_20_53 VDD VSS sg13g2_fill_2
XFILLER_0_410 VDD VSS sg13g2_decap_8
XFILLER_1_922 VDD VSS sg13g2_decap_4
XFILLER_20_97 VDD VSS sg13g2_decap_8
XFILLER_96_57 VDD VSS sg13g2_fill_1
XFILLER_0_487 VDD VSS sg13g2_decap_8
XFILLER_88_594 VDD VSS sg13g2_decap_8
XFILLER_88_572 VDD VSS sg13g2_decap_8
XFILLER_48_469 VDD VSS sg13g2_decap_8
XFILLER_75_222 VDD VSS sg13g2_decap_4
XFILLER_29_694 VDD VSS sg13g2_decap_8
XFILLER_44_631 VDD VSS sg13g2_decap_8
XFILLER_17_867 VDD VSS sg13g2_fill_2
XFILLER_32_804 VDD VSS sg13g2_fill_1
XFILLER_43_141 VDD VSS sg13g2_fill_1
XFILLER_45_50 VDD VSS sg13g2_fill_1
XFILLER_90_269 VDD VSS sg13g2_decap_8
XFILLER_43_174 VDD VSS sg13g2_decap_8
XFILLER_71_472 VDD VSS sg13g2_decap_8
XFILLER_77_7 VDD VSS sg13g2_decap_8
XFILLER_8_543 VDD VSS sg13g2_decap_8
XFILLER_8_598 VDD VSS sg13g2_decap_8
XFILLER_99_804 VDD VSS sg13g2_decap_4
XFILLER_4_760 VDD VSS sg13g2_decap_8
XFILLER_6_99 VDD VSS sg13g2_decap_8
X_3310_ _4784_/Q _4782_/Q _4783_/Q _3310_/Y VDD VSS sg13g2_nor3_1
XFILLER_98_303 VDD VSS sg13g2_decap_8
X_4290_ _4290_/RESET_B VSS VDD _4290_/D _4290_/Q _4559_/CLK sg13g2_dfrbpq_1
XFILLER_101_809 VDD VSS sg13g2_decap_8
XFILLER_113_669 VDD VSS sg13g2_decap_8
X_3241_ _4006_/A _3242_/B _3279_/A VDD VSS sg13g2_nor2_1
XFILLER_79_583 VDD VSS sg13g2_decap_8
X_3172_ _3174_/B _3171_/Y _3173_/B VDD VSS sg13g2_nor2b_1
XFILLER_66_277 VDD VSS sg13g2_decap_4
XFILLER_82_726 VDD VSS sg13g2_decap_8
XFILLER_54_439 VDD VSS sg13g2_decap_8
XFILLER_34_130 VDD VSS sg13g2_fill_2
XFILLER_35_664 VDD VSS sg13g2_decap_8
XFILLER_22_314 VDD VSS sg13g2_decap_8
XFILLER_62_472 VDD VSS sg13g2_decap_8
XFILLER_34_196 VDD VSS sg13g2_decap_8
X_2956_ _3009_/A _2956_/B _2956_/Y VDD VSS sg13g2_nor2_1
X_2887_ hold911/X _3095_/A0 _2896_/S _2887_/X VDD VSS sg13g2_mux2_1
X_4626_ fanout284/X VSS VDD _4626_/D _4626_/Q _4737_/CLK sg13g2_dfrbpq_1
XFILLER_2_708 VDD VSS sg13g2_decap_8
Xhold543 _4856_/Q VDD VSS _4928_/D sg13g2_dlygate4sd3_1
Xhold554 _3519_/X VDD VSS _4689_/D sg13g2_dlygate4sd3_1
X_4557_ fanout297/X VSS VDD _4557_/D _4557_/Q _4960_/CLK sg13g2_dfrbpq_1
XFILLER_104_647 VDD VSS sg13g2_decap_8
XFILLER_1_229 VDD VSS sg13g2_decap_4
Xhold565 _3529_/Y VDD VSS _4691_/D sg13g2_dlygate4sd3_1
Xhold576 _4555_/Q VDD VSS _3134_/A sg13g2_dlygate4sd3_1
Xhold587 _2573_/Y VDD VSS _4888_/D sg13g2_dlygate4sd3_1
X_4488_ fanout298/X VSS VDD _4488_/D _4488_/Q _4976_/CLK sg13g2_dfrbpq_1
X_3508_ _2652_/A VDD _3508_/Y VSS _3503_/A _3513_/B sg13g2_o21ai_1
XFILLER_58_701 VDD VSS sg13g2_decap_8
Xhold598 _2469_/Y VDD VSS _4849_/D sg13g2_dlygate4sd3_1
X_3439_ _3471_/B _3475_/C _3439_/A _3439_/Y VDD VSS sg13g2_nand3_1
XFILLER_106_67 VDD VSS sg13g2_decap_8
XFILLER_46_907 VDD VSS sg13g2_decap_4
XFILLER_58_756 VDD VSS sg13g2_decap_4
XFILLER_66_49 VDD VSS sg13g2_decap_8
Xhold1210 _2920_/X VDD VSS _4352_/D sg13g2_dlygate4sd3_1
Xhold1221 _4331_/Q VDD VSS _2898_/A0 sg13g2_dlygate4sd3_1
Xhold1232 _4814_/Q VDD VSS _3922_/A sg13g2_dlygate4sd3_1
Xhold1243 _2800_/Y VDD VSS _2801_/C sg13g2_dlygate4sd3_1
XFILLER_100_875 VDD VSS sg13g2_decap_8
XFILLER_100_897 VDD VSS sg13g2_decap_8
Xhold1254 _4431_/Q VDD VSS _3004_/A0 sg13g2_dlygate4sd3_1
Xhold1265 _4523_/Q VDD VSS _3099_/A0 sg13g2_dlygate4sd3_1
Xhold1276 _4285_/Q VDD VSS _2848_/A0 sg13g2_dlygate4sd3_1
XFILLER_85_586 VDD VSS sg13g2_decap_8
XFILLER_85_575 VDD VSS sg13g2_fill_2
XFILLER_72_214 VDD VSS sg13g2_decap_8
Xhold1287 _4549_/Q VDD VSS _3125_/A1 sg13g2_dlygate4sd3_1
Xhold1298 _3476_/Y VDD VSS _4675_/D sg13g2_dlygate4sd3_1
XFILLER_13_314 VDD VSS sg13g2_decap_4
XFILLER_14_826 VDD VSS sg13g2_fill_2
XFILLER_25_185 VDD VSS sg13g2_decap_8
XFILLER_25_196 VDD VSS sg13g2_fill_2
XFILLER_13_369 VDD VSS sg13g2_fill_2
XFILLER_22_870 VDD VSS sg13g2_fill_2
XFILLER_9_329 VDD VSS sg13g2_decap_8
XFILLER_108_920 VDD VSS sg13g2_decap_4
XFILLER_5_546 VDD VSS sg13g2_decap_4
XFILLER_103_0 VDD VSS sg13g2_decap_8
XFILLER_107_485 VDD VSS sg13g2_decap_8
XFILLER_0_273 VDD VSS sg13g2_decap_8
XFILLER_110_639 VDD VSS sg13g2_decap_8
XFILLER_1_796 VDD VSS sg13g2_decap_8
XFILLER_49_723 VDD VSS sg13g2_decap_8
XFILLER_95_328 VDD VSS sg13g2_decap_4
XFILLER_76_553 VDD VSS sg13g2_decap_8
X_4336__390 VDD VSS _4336_/RESET_B sg13g2_tiehi
XFILLER_36_439 VDD VSS sg13g2_decap_8
XFILLER_63_225 VDD VSS sg13g2_fill_2
XFILLER_16_130 VDD VSS sg13g2_decap_8
XFILLER_44_450 VDD VSS sg13g2_fill_1
XFILLER_72_770 VDD VSS sg13g2_fill_1
XFILLER_91_589 VDD VSS sg13g2_decap_8
XFILLER_31_177 VDD VSS sg13g2_decap_8
X_3790_ _3789_/Y VDD _3790_/Y VSS _4257_/A _3789_/B sg13g2_o21ai_1
X_2810_ _2812_/B VDD _2810_/Y VSS _2420_/A _2412_/D sg13g2_o21ai_1
X_2741_ _2741_/A _2741_/B _4949_/D VDD VSS sg13g2_nor2_1
XFILLER_9_863 VDD VSS sg13g2_decap_8
X_4411_ _4411_/RESET_B VSS VDD _4411_/D _4411_/Q _4931_/CLK sg13g2_dfrbpq_1
X_4343__383 VDD VSS _4343_/RESET_B sg13g2_tiehi
X_2672_ VDD VSS _2671_/Y _4687_/Q _2670_/Y _3511_/A _2672_/Y _2665_/X sg13g2_a221oi_1
X_4342_ _4342_/RESET_B VSS VDD _4342_/D _4342_/Q _4973_/CLK sg13g2_dfrbpq_1
Xfanout308 fanout309/X fanout308/X VDD VSS sg13g2_buf_1
Xfanout319 fanout320/X fanout319/X VDD VSS sg13g2_buf_1
X_4273_ _4273_/RESET_B VSS VDD _4273_/D _4273_/Q _4967_/CLK sg13g2_dfrbpq_1
XFILLER_87_807 VDD VSS sg13g2_decap_8
XFILLER_100_116 VDD VSS sg13g2_decap_8
XFILLER_113_488 VDD VSS sg13g2_fill_1
X_3224_ _3224_/B _3224_/A _3224_/X VDD VSS sg13g2_xor2_1
XFILLER_86_328 VDD VSS sg13g2_decap_8
.ends
